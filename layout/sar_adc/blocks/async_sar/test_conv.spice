.subckt async_sar sample_en done vdd dout[0] dout[3] dout[5] dout[6] dout[7] comp_out_p dout[1] dout[2] dout[4] comp_done rst_latch start dac_in[0] dac_in[1] dac_in[2] dac_in[3] dac_in[4] dac_in[5] dac_in[6] dac_in[7] vss
x_inv_srclk_M5 comp_done_b comp_done vdd vdd pfet_03v3 L=0.28u W=0.80u nf=1
x_inv_srclk_M6 comp_done_b comp_done vss vss nfet_03v3 L=0.28u W=0.42u nf=1
x_sr8_x1_x_inv_d_M5 x_sr8_x1_D_b vss vdd vdd pfet_03v3 L=0.28u W=0.80u nf=1
x_sr8_x1_x_inv_d_M6 x_sr8_x1_D_b vss vss vss nfet_03v3 L=0.28u W=0.42u nf=1
x_sr8_x1_x_dff_M1 x_sr8_x1_x_dff_clk_n comp_done_b vdd vdd pfet_03v3 L=0.28u W=1.0u nf=1
x_sr8_x1_x_dff_M2 x_sr8_x1_x_dff_clk_n comp_done_b vss vss nfet_03v3 L=0.28u W=0.50u nf=1
x_sr8_x1_x_dff_M3 x_sr8_x1_x_dff_M x_sr8_x1_x_dff_clk_n x_sr8_x1_x_dff_D_int vdd pfet_03v3 L=0.28u W=1.0u nf=1
x_sr8_x1_x_dff_M4 x_sr8_x1_x_dff_D_int comp_done_b x_sr8_x1_x_dff_M vss nfet_03v3 L=0.28u W=0.50u nf=1
x_sr8_x1_x_dff_M5 x_sr8_x1_x_dff_M_bar x_sr8_x1_x_dff_M vdd vdd pfet_03v3 L=0.28u W=1.0u nf=1
x_sr8_x1_x_dff_M6 x_sr8_x1_x_dff_M_bar x_sr8_x1_x_dff_M vss vss nfet_03v3 L=0.28u W=0.50u nf=1
x_sr8_x1_x_dff_M7 x_sr8_x1_x_dff_M x_sr8_x1_x_dff_M_bar vdd vdd pfet_03v3 L=2.0u W=0.42u nf=1
x_sr8_x1_x_dff_M8 x_sr8_x1_x_dff_M x_sr8_x1_x_dff_M_bar vss vss nfet_03v3 L=2.4u W=0.42u nf=1
x_sr8_x1_x_dff_M9 x_sr8_x1_x_dff_S comp_done_b x_sr8_x1_x_dff_M_bar vdd pfet_03v3 L=0.28u W=1.0u nf=1
x_sr8_x1_x_dff_M10 x_sr8_x1_x_dff_M_bar x_sr8_x1_x_dff_clk_n x_sr8_x1_x_dff_S vss nfet_03v3 L=0.28u W=0.50u nf=1
x_sr8_x1_x_dff_M11 x_sr8_x1_x_dff_Q_bar x_sr8_x1_x_dff_S vdd vdd pfet_03v3 L=0.28u W=1.0u nf=1
x_sr8_x1_x_dff_M12 x_sr8_x1_x_dff_Q_bar rst_n_int vdd vdd pfet_03v3 L=0.28u W=1.0u nf=1
x_sr8_x1_x_dff_M13 x_sr8_x1_x_dff_Q_bar x_sr8_x1_x_dff_S x_sr8_x1_x_dff_net1 vss nfet_03v3 L=0.28u W=0.50u nf=1
x_sr8_x1_x_dff_M14 x_sr8_x1_x_dff_net1 rst_n_int vss vss nfet_03v3 L=0.28u W=0.50u nf=1
x_sr8_x1_x_dff_M15 x_sr8_x1_net1 x_sr8_x1_x_dff_Q_bar vdd vdd pfet_03v3 L=0.28u W=1.0u nf=1
x_sr8_x1_x_dff_M16 x_sr8_x1_net1 x_sr8_x1_x_dff_Q_bar vss vss nfet_03v3 L=0.28u W=0.50u nf=1
x_sr8_x1_x_dff_M17 x_sr8_x1_x_dff_S x_sr8_x1_x_dff_Q_bar vdd vdd pfet_03v3 L=2.0u W=0.42u nf=1
x_sr8_x1_x_dff_M18 x_sr8_x1_x_dff_S x_sr8_x1_x_dff_Q_bar vss vss nfet_03v3 L=2.4u W=0.42u nf=1
x_sr8_x1_x_dff_M19 x_sr8_x1_x_dff_D_int x_sr8_x1_D_b vdd vdd pfet_03v3 L=0.28u W=1.0u nf=1
x_sr8_x1_x_dff_M20 x_sr8_x1_x_dff_D_int x_sr8_x1_D_b vss vss nfet_03v3 L=0.28u W=0.50u nf=1
x_sr8_x1_x_inv_q_M5 Q0 x_sr8_x1_net1 vdd vdd pfet_03v3 L=0.28u W=0.80u nf=1
x_sr8_x1_x_inv_q_M6 Q0 x_sr8_x1_net1 vss vss nfet_03v3 L=0.28u W=0.42u nf=1
x_sr8_x2_M1 x_sr8_x2_clk_n comp_done_b vdd vdd pfet_03v3 L=0.28u W=1.0u nf=1
x_sr8_x2_M2 x_sr8_x2_clk_n comp_done_b vss vss nfet_03v3 L=0.28u W=0.50u nf=1
x_sr8_x2_M3 x_sr8_x2_M x_sr8_x2_clk_n x_sr8_x2_D_int vdd pfet_03v3 L=0.28u W=1.0u nf=1
x_sr8_x2_M4 x_sr8_x2_D_int comp_done_b x_sr8_x2_M vss nfet_03v3 L=0.28u W=0.50u nf=1
x_sr8_x2_M5 x_sr8_x2_M_bar x_sr8_x2_M vdd vdd pfet_03v3 L=0.28u W=1.0u nf=1
x_sr8_x2_M6 x_sr8_x2_M_bar x_sr8_x2_M vss vss nfet_03v3 L=0.28u W=0.50u nf=1
x_sr8_x2_M7 x_sr8_x2_M x_sr8_x2_M_bar vdd vdd pfet_03v3 L=2.0u W=0.42u nf=1
x_sr8_x2_M8 x_sr8_x2_M x_sr8_x2_M_bar vss vss nfet_03v3 L=2.4u W=0.42u nf=1
x_sr8_x2_M9 x_sr8_x2_S comp_done_b x_sr8_x2_M_bar vdd pfet_03v3 L=0.28u W=1.0u nf=1
x_sr8_x2_M10 x_sr8_x2_M_bar x_sr8_x2_clk_n x_sr8_x2_S vss nfet_03v3 L=0.28u W=0.50u nf=1
x_sr8_x2_M11 x_sr8_x2_Q_bar x_sr8_x2_S vdd vdd pfet_03v3 L=0.28u W=1.0u nf=1
x_sr8_x2_M12 x_sr8_x2_Q_bar rst_n_int vdd vdd pfet_03v3 L=0.28u W=1.0u nf=1
x_sr8_x2_M13 x_sr8_x2_Q_bar x_sr8_x2_S x_sr8_x2_net1 vss nfet_03v3 L=0.28u W=0.50u nf=1
x_sr8_x2_M14 x_sr8_x2_net1 rst_n_int vss vss nfet_03v3 L=0.28u W=0.50u nf=1
x_sr8_x2_M15 Q1 x_sr8_x2_Q_bar vdd vdd pfet_03v3 L=0.28u W=1.0u nf=1
x_sr8_x2_M16 Q1 x_sr8_x2_Q_bar vss vss nfet_03v3 L=0.28u W=0.50u nf=1
x_sr8_x2_M17 x_sr8_x2_S x_sr8_x2_Q_bar vdd vdd pfet_03v3 L=2.0u W=0.42u nf=1
x_sr8_x2_M18 x_sr8_x2_S x_sr8_x2_Q_bar vss vss nfet_03v3 L=2.4u W=0.42u nf=1
x_sr8_x2_M19 x_sr8_x2_D_int Q0 vdd vdd pfet_03v3 L=0.28u W=1.0u nf=1
x_sr8_x2_M20 x_sr8_x2_D_int Q0 vss vss nfet_03v3 L=0.28u W=0.50u nf=1
x_sr8_x3_M1 x_sr8_x3_clk_n comp_done_b vdd vdd pfet_03v3 L=0.28u W=1.0u nf=1
x_sr8_x3_M2 x_sr8_x3_clk_n comp_done_b vss vss nfet_03v3 L=0.28u W=0.50u nf=1
x_sr8_x3_M3 x_sr8_x3_M x_sr8_x3_clk_n x_sr8_x3_D_int vdd pfet_03v3 L=0.28u W=1.0u nf=1
x_sr8_x3_M4 x_sr8_x3_D_int comp_done_b x_sr8_x3_M vss nfet_03v3 L=0.28u W=0.50u nf=1
x_sr8_x3_M5 x_sr8_x3_M_bar x_sr8_x3_M vdd vdd pfet_03v3 L=0.28u W=1.0u nf=1
x_sr8_x3_M6 x_sr8_x3_M_bar x_sr8_x3_M vss vss nfet_03v3 L=0.28u W=0.50u nf=1
x_sr8_x3_M7 x_sr8_x3_M x_sr8_x3_M_bar vdd vdd pfet_03v3 L=2.0u W=0.42u nf=1
x_sr8_x3_M8 x_sr8_x3_M x_sr8_x3_M_bar vss vss nfet_03v3 L=2.4u W=0.42u nf=1
x_sr8_x3_M9 x_sr8_x3_S comp_done_b x_sr8_x3_M_bar vdd pfet_03v3 L=0.28u W=1.0u nf=1
x_sr8_x3_M10 x_sr8_x3_M_bar x_sr8_x3_clk_n x_sr8_x3_S vss nfet_03v3 L=0.28u W=0.50u nf=1
x_sr8_x3_M11 x_sr8_x3_Q_bar x_sr8_x3_S vdd vdd pfet_03v3 L=0.28u W=1.0u nf=1
x_sr8_x3_M12 x_sr8_x3_Q_bar rst_n_int vdd vdd pfet_03v3 L=0.28u W=1.0u nf=1
x_sr8_x3_M13 x_sr8_x3_Q_bar x_sr8_x3_S x_sr8_x3_net1 vss nfet_03v3 L=0.28u W=0.50u nf=1
x_sr8_x3_M14 x_sr8_x3_net1 rst_n_int vss vss nfet_03v3 L=0.28u W=0.50u nf=1
x_sr8_x3_M15 Q2 x_sr8_x3_Q_bar vdd vdd pfet_03v3 L=0.28u W=1.0u nf=1
x_sr8_x3_M16 Q2 x_sr8_x3_Q_bar vss vss nfet_03v3 L=0.28u W=0.50u nf=1
x_sr8_x3_M17 x_sr8_x3_S x_sr8_x3_Q_bar vdd vdd pfet_03v3 L=2.0u W=0.42u nf=1
x_sr8_x3_M18 x_sr8_x3_S x_sr8_x3_Q_bar vss vss nfet_03v3 L=2.4u W=0.42u nf=1
x_sr8_x3_M19 x_sr8_x3_D_int Q1 vdd vdd pfet_03v3 L=0.28u W=1.0u nf=1
x_sr8_x3_M20 x_sr8_x3_D_int Q1 vss vss nfet_03v3 L=0.28u W=0.50u nf=1
x_sr8_x4_M1 x_sr8_x4_clk_n comp_done_b vdd vdd pfet_03v3 L=0.28u W=1.0u nf=1
x_sr8_x4_M2 x_sr8_x4_clk_n comp_done_b vss vss nfet_03v3 L=0.28u W=0.50u nf=1
x_sr8_x4_M3 x_sr8_x4_M x_sr8_x4_clk_n x_sr8_x4_D_int vdd pfet_03v3 L=0.28u W=1.0u nf=1
x_sr8_x4_M4 x_sr8_x4_D_int comp_done_b x_sr8_x4_M vss nfet_03v3 L=0.28u W=0.50u nf=1
x_sr8_x4_M5 x_sr8_x4_M_bar x_sr8_x4_M vdd vdd pfet_03v3 L=0.28u W=1.0u nf=1
x_sr8_x4_M6 x_sr8_x4_M_bar x_sr8_x4_M vss vss nfet_03v3 L=0.28u W=0.50u nf=1
x_sr8_x4_M7 x_sr8_x4_M x_sr8_x4_M_bar vdd vdd pfet_03v3 L=2.0u W=0.42u nf=1
x_sr8_x4_M8 x_sr8_x4_M x_sr8_x4_M_bar vss vss nfet_03v3 L=2.4u W=0.42u nf=1
x_sr8_x4_M9 x_sr8_x4_S comp_done_b x_sr8_x4_M_bar vdd pfet_03v3 L=0.28u W=1.0u nf=1
x_sr8_x4_M10 x_sr8_x4_M_bar x_sr8_x4_clk_n x_sr8_x4_S vss nfet_03v3 L=0.28u W=0.50u nf=1
x_sr8_x4_M11 x_sr8_x4_Q_bar x_sr8_x4_S vdd vdd pfet_03v3 L=0.28u W=1.0u nf=1
x_sr8_x4_M12 x_sr8_x4_Q_bar rst_n_int vdd vdd pfet_03v3 L=0.28u W=1.0u nf=1
x_sr8_x4_M13 x_sr8_x4_Q_bar x_sr8_x4_S x_sr8_x4_net1 vss nfet_03v3 L=0.28u W=0.50u nf=1
x_sr8_x4_M14 x_sr8_x4_net1 rst_n_int vss vss nfet_03v3 L=0.28u W=0.50u nf=1
x_sr8_x4_M15 Q3 x_sr8_x4_Q_bar vdd vdd pfet_03v3 L=0.28u W=1.0u nf=1
x_sr8_x4_M16 Q3 x_sr8_x4_Q_bar vss vss nfet_03v3 L=0.28u W=0.50u nf=1
x_sr8_x4_M17 x_sr8_x4_S x_sr8_x4_Q_bar vdd vdd pfet_03v3 L=2.0u W=0.42u nf=1
x_sr8_x4_M18 x_sr8_x4_S x_sr8_x4_Q_bar vss vss nfet_03v3 L=2.4u W=0.42u nf=1
x_sr8_x4_M19 x_sr8_x4_D_int Q2 vdd vdd pfet_03v3 L=0.28u W=1.0u nf=1
x_sr8_x4_M20 x_sr8_x4_D_int Q2 vss vss nfet_03v3 L=0.28u W=0.50u nf=1
x_sr8_x5_M1 x_sr8_x5_clk_n comp_done_b vdd vdd pfet_03v3 L=0.28u W=1.0u nf=1
x_sr8_x5_M2 x_sr8_x5_clk_n comp_done_b vss vss nfet_03v3 L=0.28u W=0.50u nf=1
x_sr8_x5_M3 x_sr8_x5_M x_sr8_x5_clk_n x_sr8_x5_D_int vdd pfet_03v3 L=0.28u W=1.0u nf=1
x_sr8_x5_M4 x_sr8_x5_D_int comp_done_b x_sr8_x5_M vss nfet_03v3 L=0.28u W=0.50u nf=1
x_sr8_x5_M5 x_sr8_x5_M_bar x_sr8_x5_M vdd vdd pfet_03v3 L=0.28u W=1.0u nf=1
x_sr8_x5_M6 x_sr8_x5_M_bar x_sr8_x5_M vss vss nfet_03v3 L=0.28u W=0.50u nf=1
x_sr8_x5_M7 x_sr8_x5_M x_sr8_x5_M_bar vdd vdd pfet_03v3 L=2.0u W=0.42u nf=1
x_sr8_x5_M8 x_sr8_x5_M x_sr8_x5_M_bar vss vss nfet_03v3 L=2.4u W=0.42u nf=1
x_sr8_x5_M9 x_sr8_x5_S comp_done_b x_sr8_x5_M_bar vdd pfet_03v3 L=0.28u W=1.0u nf=1
x_sr8_x5_M10 x_sr8_x5_M_bar x_sr8_x5_clk_n x_sr8_x5_S vss nfet_03v3 L=0.28u W=0.50u nf=1
x_sr8_x5_M11 x_sr8_x5_Q_bar x_sr8_x5_S vdd vdd pfet_03v3 L=0.28u W=1.0u nf=1
x_sr8_x5_M12 x_sr8_x5_Q_bar rst_n_int vdd vdd pfet_03v3 L=0.28u W=1.0u nf=1
x_sr8_x5_M13 x_sr8_x5_Q_bar x_sr8_x5_S x_sr8_x5_net1 vss nfet_03v3 L=0.28u W=0.50u nf=1
x_sr8_x5_M14 x_sr8_x5_net1 rst_n_int vss vss nfet_03v3 L=0.28u W=0.50u nf=1
x_sr8_x5_M15 Q4 x_sr8_x5_Q_bar vdd vdd pfet_03v3 L=0.28u W=1.0u nf=1
x_sr8_x5_M16 Q4 x_sr8_x5_Q_bar vss vss nfet_03v3 L=0.28u W=0.50u nf=1
x_sr8_x5_M17 x_sr8_x5_S x_sr8_x5_Q_bar vdd vdd pfet_03v3 L=2.0u W=0.42u nf=1
x_sr8_x5_M18 x_sr8_x5_S x_sr8_x5_Q_bar vss vss nfet_03v3 L=2.4u W=0.42u nf=1
x_sr8_x5_M19 x_sr8_x5_D_int Q3 vdd vdd pfet_03v3 L=0.28u W=1.0u nf=1
x_sr8_x5_M20 x_sr8_x5_D_int Q3 vss vss nfet_03v3 L=0.28u W=0.50u nf=1
x_sr8_x6_M1 x_sr8_x6_clk_n comp_done_b vdd vdd pfet_03v3 L=0.28u W=1.0u nf=1
x_sr8_x6_M2 x_sr8_x6_clk_n comp_done_b vss vss nfet_03v3 L=0.28u W=0.50u nf=1
x_sr8_x6_M3 x_sr8_x6_M x_sr8_x6_clk_n x_sr8_x6_D_int vdd pfet_03v3 L=0.28u W=1.0u nf=1
x_sr8_x6_M4 x_sr8_x6_D_int comp_done_b x_sr8_x6_M vss nfet_03v3 L=0.28u W=0.50u nf=1
x_sr8_x6_M5 x_sr8_x6_M_bar x_sr8_x6_M vdd vdd pfet_03v3 L=0.28u W=1.0u nf=1
x_sr8_x6_M6 x_sr8_x6_M_bar x_sr8_x6_M vss vss nfet_03v3 L=0.28u W=0.50u nf=1
x_sr8_x6_M7 x_sr8_x6_M x_sr8_x6_M_bar vdd vdd pfet_03v3 L=2.0u W=0.42u nf=1
x_sr8_x6_M8 x_sr8_x6_M x_sr8_x6_M_bar vss vss nfet_03v3 L=2.4u W=0.42u nf=1
x_sr8_x6_M9 x_sr8_x6_S comp_done_b x_sr8_x6_M_bar vdd pfet_03v3 L=0.28u W=1.0u nf=1
x_sr8_x6_M10 x_sr8_x6_M_bar x_sr8_x6_clk_n x_sr8_x6_S vss nfet_03v3 L=0.28u W=0.50u nf=1
x_sr8_x6_M11 x_sr8_x6_Q_bar x_sr8_x6_S vdd vdd pfet_03v3 L=0.28u W=1.0u nf=1
x_sr8_x6_M12 x_sr8_x6_Q_bar rst_n_int vdd vdd pfet_03v3 L=0.28u W=1.0u nf=1
x_sr8_x6_M13 x_sr8_x6_Q_bar x_sr8_x6_S x_sr8_x6_net1 vss nfet_03v3 L=0.28u W=0.50u nf=1
x_sr8_x6_M14 x_sr8_x6_net1 rst_n_int vss vss nfet_03v3 L=0.28u W=0.50u nf=1
x_sr8_x6_M15 Q5 x_sr8_x6_Q_bar vdd vdd pfet_03v3 L=0.28u W=1.0u nf=1
x_sr8_x6_M16 Q5 x_sr8_x6_Q_bar vss vss nfet_03v3 L=0.28u W=0.50u nf=1
x_sr8_x6_M17 x_sr8_x6_S x_sr8_x6_Q_bar vdd vdd pfet_03v3 L=2.0u W=0.42u nf=1
x_sr8_x6_M18 x_sr8_x6_S x_sr8_x6_Q_bar vss vss nfet_03v3 L=2.4u W=0.42u nf=1
x_sr8_x6_M19 x_sr8_x6_D_int Q4 vdd vdd pfet_03v3 L=0.28u W=1.0u nf=1
x_sr8_x6_M20 x_sr8_x6_D_int Q4 vss vss nfet_03v3 L=0.28u W=0.50u nf=1
x_sr8_x7_M1 x_sr8_x7_clk_n comp_done_b vdd vdd pfet_03v3 L=0.28u W=1.0u nf=1
x_sr8_x7_M2 x_sr8_x7_clk_n comp_done_b vss vss nfet_03v3 L=0.28u W=0.50u nf=1
x_sr8_x7_M3 x_sr8_x7_M x_sr8_x7_clk_n x_sr8_x7_D_int vdd pfet_03v3 L=0.28u W=1.0u nf=1
x_sr8_x7_M4 x_sr8_x7_D_int comp_done_b x_sr8_x7_M vss nfet_03v3 L=0.28u W=0.50u nf=1
x_sr8_x7_M5 x_sr8_x7_M_bar x_sr8_x7_M vdd vdd pfet_03v3 L=0.28u W=1.0u nf=1
x_sr8_x7_M6 x_sr8_x7_M_bar x_sr8_x7_M vss vss nfet_03v3 L=0.28u W=0.50u nf=1
x_sr8_x7_M7 x_sr8_x7_M x_sr8_x7_M_bar vdd vdd pfet_03v3 L=2.0u W=0.42u nf=1
x_sr8_x7_M8 x_sr8_x7_M x_sr8_x7_M_bar vss vss nfet_03v3 L=2.4u W=0.42u nf=1
x_sr8_x7_M9 x_sr8_x7_S comp_done_b x_sr8_x7_M_bar vdd pfet_03v3 L=0.28u W=1.0u nf=1
x_sr8_x7_M10 x_sr8_x7_M_bar x_sr8_x7_clk_n x_sr8_x7_S vss nfet_03v3 L=0.28u W=0.50u nf=1
x_sr8_x7_M11 x_sr8_x7_Q_bar x_sr8_x7_S vdd vdd pfet_03v3 L=0.28u W=1.0u nf=1
x_sr8_x7_M12 x_sr8_x7_Q_bar rst_n_int vdd vdd pfet_03v3 L=0.28u W=1.0u nf=1
x_sr8_x7_M13 x_sr8_x7_Q_bar x_sr8_x7_S x_sr8_x7_net1 vss nfet_03v3 L=0.28u W=0.50u nf=1
x_sr8_x7_M14 x_sr8_x7_net1 rst_n_int vss vss nfet_03v3 L=0.28u W=0.50u nf=1
x_sr8_x7_M15 Q6 x_sr8_x7_Q_bar vdd vdd pfet_03v3 L=0.28u W=1.0u nf=1
x_sr8_x7_M16 Q6 x_sr8_x7_Q_bar vss vss nfet_03v3 L=0.28u W=0.50u nf=1
x_sr8_x7_M17 x_sr8_x7_S x_sr8_x7_Q_bar vdd vdd pfet_03v3 L=2.0u W=0.42u nf=1
x_sr8_x7_M18 x_sr8_x7_S x_sr8_x7_Q_bar vss vss nfet_03v3 L=2.4u W=0.42u nf=1
x_sr8_x7_M19 x_sr8_x7_D_int Q5 vdd vdd pfet_03v3 L=0.28u W=1.0u nf=1
x_sr8_x7_M20 x_sr8_x7_D_int Q5 vss vss nfet_03v3 L=0.28u W=0.50u nf=1
x_sr8_x8_M1 x_sr8_x8_clk_n comp_done_b vdd vdd pfet_03v3 L=0.28u W=1.0u nf=1
x_sr8_x8_M2 x_sr8_x8_clk_n comp_done_b vss vss nfet_03v3 L=0.28u W=0.50u nf=1
x_sr8_x8_M3 x_sr8_x8_M x_sr8_x8_clk_n x_sr8_x8_D_int vdd pfet_03v3 L=0.28u W=1.0u nf=1
x_sr8_x8_M4 x_sr8_x8_D_int comp_done_b x_sr8_x8_M vss nfet_03v3 L=0.28u W=0.50u nf=1
x_sr8_x8_M5 x_sr8_x8_M_bar x_sr8_x8_M vdd vdd pfet_03v3 L=0.28u W=1.0u nf=1
x_sr8_x8_M6 x_sr8_x8_M_bar x_sr8_x8_M vss vss nfet_03v3 L=0.28u W=0.50u nf=1
x_sr8_x8_M7 x_sr8_x8_M x_sr8_x8_M_bar vdd vdd pfet_03v3 L=2.0u W=0.42u nf=1
x_sr8_x8_M8 x_sr8_x8_M x_sr8_x8_M_bar vss vss nfet_03v3 L=2.4u W=0.42u nf=1
x_sr8_x8_M9 x_sr8_x8_S comp_done_b x_sr8_x8_M_bar vdd pfet_03v3 L=0.28u W=1.0u nf=1
x_sr8_x8_M10 x_sr8_x8_M_bar x_sr8_x8_clk_n x_sr8_x8_S vss nfet_03v3 L=0.28u W=0.50u nf=1
x_sr8_x8_M11 x_sr8_x8_Q_bar x_sr8_x8_S vdd vdd pfet_03v3 L=0.28u W=1.0u nf=1
x_sr8_x8_M12 x_sr8_x8_Q_bar rst_n_int vdd vdd pfet_03v3 L=0.28u W=1.0u nf=1
x_sr8_x8_M13 x_sr8_x8_Q_bar x_sr8_x8_S x_sr8_x8_net1 vss nfet_03v3 L=0.28u W=0.50u nf=1
x_sr8_x8_M14 x_sr8_x8_net1 rst_n_int vss vss nfet_03v3 L=0.28u W=0.50u nf=1
x_sr8_x8_M15 Q7 x_sr8_x8_Q_bar vdd vdd pfet_03v3 L=0.28u W=1.0u nf=1
x_sr8_x8_M16 Q7 x_sr8_x8_Q_bar vss vss nfet_03v3 L=0.28u W=0.50u nf=1
x_sr8_x8_M17 x_sr8_x8_S x_sr8_x8_Q_bar vdd vdd pfet_03v3 L=2.0u W=0.42u nf=1
x_sr8_x8_M18 x_sr8_x8_S x_sr8_x8_Q_bar vss vss nfet_03v3 L=2.4u W=0.42u nf=1
x_sr8_x8_M19 x_sr8_x8_D_int Q6 vdd vdd pfet_03v3 L=0.28u W=1.0u nf=1
x_sr8_x8_M20 x_sr8_x8_D_int Q6 vss vss nfet_03v3 L=0.28u W=0.50u nf=1
x_sr8_x9_M1 x_sr8_x9_clk_n comp_done_b vdd vdd pfet_03v3 L=0.28u W=1.0u nf=1
x_sr8_x9_M2 x_sr8_x9_clk_n comp_done_b vss vss nfet_03v3 L=0.28u W=0.50u nf=1
x_sr8_x9_M3 x_sr8_x9_M x_sr8_x9_clk_n x_sr8_x9_D_int vdd pfet_03v3 L=0.28u W=1.0u nf=1
x_sr8_x9_M4 x_sr8_x9_D_int comp_done_b x_sr8_x9_M vss nfet_03v3 L=0.28u W=0.50u nf=1
x_sr8_x9_M5 x_sr8_x9_M_bar x_sr8_x9_M vdd vdd pfet_03v3 L=0.28u W=1.0u nf=1
x_sr8_x9_M6 x_sr8_x9_M_bar x_sr8_x9_M vss vss nfet_03v3 L=0.28u W=0.50u nf=1
x_sr8_x9_M7 x_sr8_x9_M x_sr8_x9_M_bar vdd vdd pfet_03v3 L=2.0u W=0.42u nf=1
x_sr8_x9_M8 x_sr8_x9_M x_sr8_x9_M_bar vss vss nfet_03v3 L=2.4u W=0.42u nf=1
x_sr8_x9_M9 x_sr8_x9_S comp_done_b x_sr8_x9_M_bar vdd pfet_03v3 L=0.28u W=1.0u nf=1
x_sr8_x9_M10 x_sr8_x9_M_bar x_sr8_x9_clk_n x_sr8_x9_S vss nfet_03v3 L=0.28u W=0.50u nf=1
x_sr8_x9_M11 x_sr8_x9_Q_bar x_sr8_x9_S vdd vdd pfet_03v3 L=0.28u W=1.0u nf=1
x_sr8_x9_M12 x_sr8_x9_Q_bar rst_n_int vdd vdd pfet_03v3 L=0.28u W=1.0u nf=1
x_sr8_x9_M13 x_sr8_x9_Q_bar x_sr8_x9_S x_sr8_x9_net1 vss nfet_03v3 L=0.28u W=0.50u nf=1
x_sr8_x9_M14 x_sr8_x9_net1 rst_n_int vss vss nfet_03v3 L=0.28u W=0.50u nf=1
x_sr8_x9_M15 sr_done x_sr8_x9_Q_bar vdd vdd pfet_03v3 L=0.28u W=1.0u nf=1
x_sr8_x9_M16 sr_done x_sr8_x9_Q_bar vss vss nfet_03v3 L=0.28u W=0.50u nf=1
x_sr8_x9_M17 x_sr8_x9_S x_sr8_x9_Q_bar vdd vdd pfet_03v3 L=2.0u W=0.42u nf=1
x_sr8_x9_M18 x_sr8_x9_S x_sr8_x9_Q_bar vss vss nfet_03v3 L=2.4u W=0.42u nf=1
x_sr8_x9_M19 x_sr8_x9_D_int Q7 vdd vdd pfet_03v3 L=0.28u W=1.0u nf=1
x_sr8_x9_M20 x_sr8_x9_D_int Q7 vss vss nfet_03v3 L=0.28u W=0.50u nf=1
x_inv_se1_M5 start_inv start vdd vdd pfet_03v3 L=0.28u W=0.80u nf=1
x_inv_se1_M6 start_inv start vss vss nfet_03v3 L=0.28u W=0.42u nf=1
x_inv_se2_M5 sample_en start_inv vdd vdd pfet_03v3 L=0.28u W=0.80u nf=1
x_inv_se2_M6 sample_en start_inv vss vss nfet_03v3 L=0.28u W=0.42u nf=1
x_inv_rst_M5 rst_n_int start vdd vdd pfet_03v3 L=0.28u W=0.80u nf=1
x_inv_rst_M6 rst_n_int start vss vss nfet_03v3 L=0.28u W=0.42u nf=1
x_bit7_x_nand_set_M2 x_bit7_x_nand_set_net1 Q0 vss vss nfet_03v3 L=0.28u W=0.50u nf=1
x_bit7_x_nand_set_M3 x_bit7_set_n comp_out_p vdd vdd pfet_03v3 L=0.28u W=1.0u nf=1
x_bit7_x_nand_set_M1 x_bit7_set_n Q0 vdd vdd pfet_03v3 L=0.28u W=1.0u nf=1
x_bit7_x_nand_set_M4 x_bit7_set_n comp_out_p x_bit7_x_nand_set_net1 vss nfet_03v3 L=0.28u W=0.50u nf=1
x_bit7_x_inv_set_M5 x_bit7_set x_bit7_set_n vdd vdd pfet_03v3 L=0.28u W=0.80u nf=1
x_bit7_x_inv_set_M6 x_bit7_set x_bit7_set_n vss vss nfet_03v3 L=0.28u W=0.42u nf=1
x_bit7_x_inv_rst_M5 x_bit7_rst rst_n_int vdd vdd pfet_03v3 L=0.28u W=0.80u nf=1
x_bit7_x_inv_rst_M6 x_bit7_rst rst_n_int vss vss nfet_03v3 L=0.28u W=0.42u nf=1
x_bit7_x_nor_q_x1_M5 x_bit7_x_nor_q_A_b x_bit7_rst vdd vdd pfet_03v3 L=0.28u W=0.80u nf=1
x_bit7_x_nor_q_x1_M6 x_bit7_x_nor_q_A_b x_bit7_rst vss vss nfet_03v3 L=0.28u W=0.42u nf=1
x_bit7_x_nor_q_x2_M5 x_bit7_x_nor_q_B_b x_bit7_bit_out_bar vdd vdd pfet_03v3 L=0.28u W=0.80u nf=1
x_bit7_x_nor_q_x2_M6 x_bit7_x_nor_q_B_b x_bit7_bit_out_bar vss vss nfet_03v3 L=0.28u W=0.42u nf=1
x_bit7_x_nor_q_x3_M2 x_bit7_x_nor_q_x3_net1 x_bit7_x_nor_q_B_b vss vss nfet_03v3 L=0.28u W=0.50u nf=1
x_bit7_x_nor_q_x3_M3 x_bit7_x_nor_q_net1 x_bit7_x_nor_q_A_b vdd vdd pfet_03v3 L=0.28u W=1.0u nf=1
x_bit7_x_nor_q_x3_M1 x_bit7_x_nor_q_net1 x_bit7_x_nor_q_B_b vdd vdd pfet_03v3 L=0.28u W=1.0u nf=1
x_bit7_x_nor_q_x3_M4 x_bit7_x_nor_q_net1 x_bit7_x_nor_q_A_b x_bit7_x_nor_q_x3_net1 vss nfet_03v3 L=0.28u W=0.50u nf=1
x_bit7_x_nor_q_x4_M5 dout[7] x_bit7_x_nor_q_net1 vdd vdd pfet_03v3 L=0.28u W=0.80u nf=1
x_bit7_x_nor_q_x4_M6 dout[7] x_bit7_x_nor_q_net1 vss vss nfet_03v3 L=0.28u W=0.42u nf=1
x_bit7_x_nor_qb_x1_M5 x_bit7_x_nor_qb_A_b x_bit7_set vdd vdd pfet_03v3 L=0.28u W=0.80u nf=1
x_bit7_x_nor_qb_x1_M6 x_bit7_x_nor_qb_A_b x_bit7_set vss vss nfet_03v3 L=0.28u W=0.42u nf=1
x_bit7_x_nor_qb_x2_M5 x_bit7_x_nor_qb_B_b dout[7] vdd vdd pfet_03v3 L=0.28u W=0.80u nf=1
x_bit7_x_nor_qb_x2_M6 x_bit7_x_nor_qb_B_b dout[7] vss vss nfet_03v3 L=0.28u W=0.42u nf=1
x_bit7_x_nor_qb_x3_M2 x_bit7_x_nor_qb_x3_net1 x_bit7_x_nor_qb_B_b vss vss nfet_03v3 L=0.28u W=0.50u nf=1
x_bit7_x_nor_qb_x3_M3 x_bit7_x_nor_qb_net1 x_bit7_x_nor_qb_A_b vdd vdd pfet_03v3 L=0.28u W=1.0u nf=1
x_bit7_x_nor_qb_x3_M1 x_bit7_x_nor_qb_net1 x_bit7_x_nor_qb_B_b vdd vdd pfet_03v3 L=0.28u W=1.0u nf=1
x_bit7_x_nor_qb_x3_M4 x_bit7_x_nor_qb_net1 x_bit7_x_nor_qb_A_b x_bit7_x_nor_qb_x3_net1 vss nfet_03v3 L=0.28u W=0.50u nf=1
x_bit7_x_nor_qb_x4_M5 x_bit7_bit_out_bar x_bit7_x_nor_qb_net1 vdd vdd pfet_03v3 L=0.28u W=0.80u nf=1
x_bit7_x_nor_qb_x4_M6 x_bit7_bit_out_bar x_bit7_x_nor_qb_net1 vss vss nfet_03v3 L=0.28u W=0.42u nf=1
x_nor_dq7_x1_M5 x_nor_dq7_A_b dout[7] vdd vdd pfet_03v3 L=0.28u W=0.80u nf=1
x_nor_dq7_x1_M6 x_nor_dq7_A_b dout[7] vss vss nfet_03v3 L=0.28u W=0.42u nf=1
x_nor_dq7_x2_M5 x_nor_dq7_B_b Q0 vdd vdd pfet_03v3 L=0.28u W=0.80u nf=1
x_nor_dq7_x2_M6 x_nor_dq7_B_b Q0 vss vss nfet_03v3 L=0.28u W=0.42u nf=1
x_nor_dq7_x3_M2 x_nor_dq7_x3_net1 x_nor_dq7_B_b vss vss nfet_03v3 L=0.28u W=0.50u nf=1
x_nor_dq7_x3_M3 x_nor_dq7_net1 x_nor_dq7_A_b vdd vdd pfet_03v3 L=0.28u W=1.0u nf=1
x_nor_dq7_x3_M1 x_nor_dq7_net1 x_nor_dq7_B_b vdd vdd pfet_03v3 L=0.28u W=1.0u nf=1
x_nor_dq7_x3_M4 x_nor_dq7_net1 x_nor_dq7_A_b x_nor_dq7_x3_net1 vss nfet_03v3 L=0.28u W=0.50u nf=1
x_nor_dq7_x4_M5 dac_n7 x_nor_dq7_net1 vdd vdd pfet_03v3 L=0.28u W=0.80u nf=1
x_nor_dq7_x4_M6 dac_n7 x_nor_dq7_net1 vss vss nfet_03v3 L=0.28u W=0.42u nf=1
x_nor_st7_x1_M5 x_nor_st7_A_b dac_n7 vdd vdd pfet_03v3 L=0.28u W=0.80u nf=1
x_nor_st7_x1_M6 x_nor_st7_A_b dac_n7 vss vss nfet_03v3 L=0.28u W=0.42u nf=1
x_nor_st7_x2_M5 x_nor_st7_B_b start vdd vdd pfet_03v3 L=0.28u W=0.80u nf=1
x_nor_st7_x2_M6 x_nor_st7_B_b start vss vss nfet_03v3 L=0.28u W=0.42u nf=1
x_nor_st7_x3_M2 x_nor_st7_x3_net1 x_nor_st7_B_b vss vss nfet_03v3 L=0.28u W=0.50u nf=1
x_nor_st7_x3_M3 x_nor_st7_net1 x_nor_st7_A_b vdd vdd pfet_03v3 L=0.28u W=1.0u nf=1
x_nor_st7_x3_M1 x_nor_st7_net1 x_nor_st7_B_b vdd vdd pfet_03v3 L=0.28u W=1.0u nf=1
x_nor_st7_x3_M4 x_nor_st7_net1 x_nor_st7_A_b x_nor_st7_x3_net1 vss nfet_03v3 L=0.28u W=0.50u nf=1
x_nor_st7_x4_M5 dac_in[7] x_nor_st7_net1 vdd vdd pfet_03v3 L=0.28u W=0.80u nf=1
x_nor_st7_x4_M6 dac_in[7] x_nor_st7_net1 vss vss nfet_03v3 L=0.28u W=0.42u nf=1
x_bit6_x_nand_set_M2 x_bit6_x_nand_set_net1 Q1 vss vss nfet_03v3 L=0.28u W=0.50u nf=1
x_bit6_x_nand_set_M3 x_bit6_set_n comp_out_p vdd vdd pfet_03v3 L=0.28u W=1.0u nf=1
x_bit6_x_nand_set_M1 x_bit6_set_n Q1 vdd vdd pfet_03v3 L=0.28u W=1.0u nf=1
x_bit6_x_nand_set_M4 x_bit6_set_n comp_out_p x_bit6_x_nand_set_net1 vss nfet_03v3 L=0.28u W=0.50u nf=1
x_bit6_x_inv_set_M5 x_bit6_set x_bit6_set_n vdd vdd pfet_03v3 L=0.28u W=0.80u nf=1
x_bit6_x_inv_set_M6 x_bit6_set x_bit6_set_n vss vss nfet_03v3 L=0.28u W=0.42u nf=1
x_bit6_x_inv_rst_M5 x_bit6_rst rst_n_int vdd vdd pfet_03v3 L=0.28u W=0.80u nf=1
x_bit6_x_inv_rst_M6 x_bit6_rst rst_n_int vss vss nfet_03v3 L=0.28u W=0.42u nf=1
x_bit6_x_nor_q_x1_M5 x_bit6_x_nor_q_A_b x_bit6_rst vdd vdd pfet_03v3 L=0.28u W=0.80u nf=1
x_bit6_x_nor_q_x1_M6 x_bit6_x_nor_q_A_b x_bit6_rst vss vss nfet_03v3 L=0.28u W=0.42u nf=1
x_bit6_x_nor_q_x2_M5 x_bit6_x_nor_q_B_b x_bit6_bit_out_bar vdd vdd pfet_03v3 L=0.28u W=0.80u nf=1
x_bit6_x_nor_q_x2_M6 x_bit6_x_nor_q_B_b x_bit6_bit_out_bar vss vss nfet_03v3 L=0.28u W=0.42u nf=1
x_bit6_x_nor_q_x3_M2 x_bit6_x_nor_q_x3_net1 x_bit6_x_nor_q_B_b vss vss nfet_03v3 L=0.28u W=0.50u nf=1
x_bit6_x_nor_q_x3_M3 x_bit6_x_nor_q_net1 x_bit6_x_nor_q_A_b vdd vdd pfet_03v3 L=0.28u W=1.0u nf=1
x_bit6_x_nor_q_x3_M1 x_bit6_x_nor_q_net1 x_bit6_x_nor_q_B_b vdd vdd pfet_03v3 L=0.28u W=1.0u nf=1
x_bit6_x_nor_q_x3_M4 x_bit6_x_nor_q_net1 x_bit6_x_nor_q_A_b x_bit6_x_nor_q_x3_net1 vss nfet_03v3 L=0.28u W=0.50u nf=1
x_bit6_x_nor_q_x4_M5 dout[6] x_bit6_x_nor_q_net1 vdd vdd pfet_03v3 L=0.28u W=0.80u nf=1
x_bit6_x_nor_q_x4_M6 dout[6] x_bit6_x_nor_q_net1 vss vss nfet_03v3 L=0.28u W=0.42u nf=1
x_bit6_x_nor_qb_x1_M5 x_bit6_x_nor_qb_A_b x_bit6_set vdd vdd pfet_03v3 L=0.28u W=0.80u nf=1
x_bit6_x_nor_qb_x1_M6 x_bit6_x_nor_qb_A_b x_bit6_set vss vss nfet_03v3 L=0.28u W=0.42u nf=1
x_bit6_x_nor_qb_x2_M5 x_bit6_x_nor_qb_B_b dout[6] vdd vdd pfet_03v3 L=0.28u W=0.80u nf=1
x_bit6_x_nor_qb_x2_M6 x_bit6_x_nor_qb_B_b dout[6] vss vss nfet_03v3 L=0.28u W=0.42u nf=1
x_bit6_x_nor_qb_x3_M2 x_bit6_x_nor_qb_x3_net1 x_bit6_x_nor_qb_B_b vss vss nfet_03v3 L=0.28u W=0.50u nf=1
x_bit6_x_nor_qb_x3_M3 x_bit6_x_nor_qb_net1 x_bit6_x_nor_qb_A_b vdd vdd pfet_03v3 L=0.28u W=1.0u nf=1
x_bit6_x_nor_qb_x3_M1 x_bit6_x_nor_qb_net1 x_bit6_x_nor_qb_B_b vdd vdd pfet_03v3 L=0.28u W=1.0u nf=1
x_bit6_x_nor_qb_x3_M4 x_bit6_x_nor_qb_net1 x_bit6_x_nor_qb_A_b x_bit6_x_nor_qb_x3_net1 vss nfet_03v3 L=0.28u W=0.50u nf=1
x_bit6_x_nor_qb_x4_M5 x_bit6_bit_out_bar x_bit6_x_nor_qb_net1 vdd vdd pfet_03v3 L=0.28u W=0.80u nf=1
x_bit6_x_nor_qb_x4_M6 x_bit6_bit_out_bar x_bit6_x_nor_qb_net1 vss vss nfet_03v3 L=0.28u W=0.42u nf=1
x_nor_dq6_x1_M5 x_nor_dq6_A_b dout[6] vdd vdd pfet_03v3 L=0.28u W=0.80u nf=1
x_nor_dq6_x1_M6 x_nor_dq6_A_b dout[6] vss vss nfet_03v3 L=0.28u W=0.42u nf=1
x_nor_dq6_x2_M5 x_nor_dq6_B_b Q1 vdd vdd pfet_03v3 L=0.28u W=0.80u nf=1
x_nor_dq6_x2_M6 x_nor_dq6_B_b Q1 vss vss nfet_03v3 L=0.28u W=0.42u nf=1
x_nor_dq6_x3_M2 x_nor_dq6_x3_net1 x_nor_dq6_B_b vss vss nfet_03v3 L=0.28u W=0.50u nf=1
x_nor_dq6_x3_M3 x_nor_dq6_net1 x_nor_dq6_A_b vdd vdd pfet_03v3 L=0.28u W=1.0u nf=1
x_nor_dq6_x3_M1 x_nor_dq6_net1 x_nor_dq6_B_b vdd vdd pfet_03v3 L=0.28u W=1.0u nf=1
x_nor_dq6_x3_M4 x_nor_dq6_net1 x_nor_dq6_A_b x_nor_dq6_x3_net1 vss nfet_03v3 L=0.28u W=0.50u nf=1
x_nor_dq6_x4_M5 dac_n6 x_nor_dq6_net1 vdd vdd pfet_03v3 L=0.28u W=0.80u nf=1
x_nor_dq6_x4_M6 dac_n6 x_nor_dq6_net1 vss vss nfet_03v3 L=0.28u W=0.42u nf=1
x_nor_st6_x1_M5 x_nor_st6_A_b dac_n6 vdd vdd pfet_03v3 L=0.28u W=0.80u nf=1
x_nor_st6_x1_M6 x_nor_st6_A_b dac_n6 vss vss nfet_03v3 L=0.28u W=0.42u nf=1
x_nor_st6_x2_M5 x_nor_st6_B_b start vdd vdd pfet_03v3 L=0.28u W=0.80u nf=1
x_nor_st6_x2_M6 x_nor_st6_B_b start vss vss nfet_03v3 L=0.28u W=0.42u nf=1
x_nor_st6_x3_M2 x_nor_st6_x3_net1 x_nor_st6_B_b vss vss nfet_03v3 L=0.28u W=0.50u nf=1
x_nor_st6_x3_M3 x_nor_st6_net1 x_nor_st6_A_b vdd vdd pfet_03v3 L=0.28u W=1.0u nf=1
x_nor_st6_x3_M1 x_nor_st6_net1 x_nor_st6_B_b vdd vdd pfet_03v3 L=0.28u W=1.0u nf=1
x_nor_st6_x3_M4 x_nor_st6_net1 x_nor_st6_A_b x_nor_st6_x3_net1 vss nfet_03v3 L=0.28u W=0.50u nf=1
x_nor_st6_x4_M5 dac_in[6] x_nor_st6_net1 vdd vdd pfet_03v3 L=0.28u W=0.80u nf=1
x_nor_st6_x4_M6 dac_in[6] x_nor_st6_net1 vss vss nfet_03v3 L=0.28u W=0.42u nf=1
x_bit5_x_nand_set_M2 x_bit5_x_nand_set_net1 Q2 vss vss nfet_03v3 L=0.28u W=0.50u nf=1
x_bit5_x_nand_set_M3 x_bit5_set_n comp_out_p vdd vdd pfet_03v3 L=0.28u W=1.0u nf=1
x_bit5_x_nand_set_M1 x_bit5_set_n Q2 vdd vdd pfet_03v3 L=0.28u W=1.0u nf=1
x_bit5_x_nand_set_M4 x_bit5_set_n comp_out_p x_bit5_x_nand_set_net1 vss nfet_03v3 L=0.28u W=0.50u nf=1
x_bit5_x_inv_set_M5 x_bit5_set x_bit5_set_n vdd vdd pfet_03v3 L=0.28u W=0.80u nf=1
x_bit5_x_inv_set_M6 x_bit5_set x_bit5_set_n vss vss nfet_03v3 L=0.28u W=0.42u nf=1
x_bit5_x_inv_rst_M5 x_bit5_rst rst_n_int vdd vdd pfet_03v3 L=0.28u W=0.80u nf=1
x_bit5_x_inv_rst_M6 x_bit5_rst rst_n_int vss vss nfet_03v3 L=0.28u W=0.42u nf=1
x_bit5_x_nor_q_x1_M5 x_bit5_x_nor_q_A_b x_bit5_rst vdd vdd pfet_03v3 L=0.28u W=0.80u nf=1
x_bit5_x_nor_q_x1_M6 x_bit5_x_nor_q_A_b x_bit5_rst vss vss nfet_03v3 L=0.28u W=0.42u nf=1
x_bit5_x_nor_q_x2_M5 x_bit5_x_nor_q_B_b x_bit5_bit_out_bar vdd vdd pfet_03v3 L=0.28u W=0.80u nf=1
x_bit5_x_nor_q_x2_M6 x_bit5_x_nor_q_B_b x_bit5_bit_out_bar vss vss nfet_03v3 L=0.28u W=0.42u nf=1
x_bit5_x_nor_q_x3_M2 x_bit5_x_nor_q_x3_net1 x_bit5_x_nor_q_B_b vss vss nfet_03v3 L=0.28u W=0.50u nf=1
x_bit5_x_nor_q_x3_M3 x_bit5_x_nor_q_net1 x_bit5_x_nor_q_A_b vdd vdd pfet_03v3 L=0.28u W=1.0u nf=1
x_bit5_x_nor_q_x3_M1 x_bit5_x_nor_q_net1 x_bit5_x_nor_q_B_b vdd vdd pfet_03v3 L=0.28u W=1.0u nf=1
x_bit5_x_nor_q_x3_M4 x_bit5_x_nor_q_net1 x_bit5_x_nor_q_A_b x_bit5_x_nor_q_x3_net1 vss nfet_03v3 L=0.28u W=0.50u nf=1
x_bit5_x_nor_q_x4_M5 dout[5] x_bit5_x_nor_q_net1 vdd vdd pfet_03v3 L=0.28u W=0.80u nf=1
x_bit5_x_nor_q_x4_M6 dout[5] x_bit5_x_nor_q_net1 vss vss nfet_03v3 L=0.28u W=0.42u nf=1
x_bit5_x_nor_qb_x1_M5 x_bit5_x_nor_qb_A_b x_bit5_set vdd vdd pfet_03v3 L=0.28u W=0.80u nf=1
x_bit5_x_nor_qb_x1_M6 x_bit5_x_nor_qb_A_b x_bit5_set vss vss nfet_03v3 L=0.28u W=0.42u nf=1
x_bit5_x_nor_qb_x2_M5 x_bit5_x_nor_qb_B_b dout[5] vdd vdd pfet_03v3 L=0.28u W=0.80u nf=1
x_bit5_x_nor_qb_x2_M6 x_bit5_x_nor_qb_B_b dout[5] vss vss nfet_03v3 L=0.28u W=0.42u nf=1
x_bit5_x_nor_qb_x3_M2 x_bit5_x_nor_qb_x3_net1 x_bit5_x_nor_qb_B_b vss vss nfet_03v3 L=0.28u W=0.50u nf=1
x_bit5_x_nor_qb_x3_M3 x_bit5_x_nor_qb_net1 x_bit5_x_nor_qb_A_b vdd vdd pfet_03v3 L=0.28u W=1.0u nf=1
x_bit5_x_nor_qb_x3_M1 x_bit5_x_nor_qb_net1 x_bit5_x_nor_qb_B_b vdd vdd pfet_03v3 L=0.28u W=1.0u nf=1
x_bit5_x_nor_qb_x3_M4 x_bit5_x_nor_qb_net1 x_bit5_x_nor_qb_A_b x_bit5_x_nor_qb_x3_net1 vss nfet_03v3 L=0.28u W=0.50u nf=1
x_bit5_x_nor_qb_x4_M5 x_bit5_bit_out_bar x_bit5_x_nor_qb_net1 vdd vdd pfet_03v3 L=0.28u W=0.80u nf=1
x_bit5_x_nor_qb_x4_M6 x_bit5_bit_out_bar x_bit5_x_nor_qb_net1 vss vss nfet_03v3 L=0.28u W=0.42u nf=1
x_nor_dq5_x1_M5 x_nor_dq5_A_b dout[5] vdd vdd pfet_03v3 L=0.28u W=0.80u nf=1
x_nor_dq5_x1_M6 x_nor_dq5_A_b dout[5] vss vss nfet_03v3 L=0.28u W=0.42u nf=1
x_nor_dq5_x2_M5 x_nor_dq5_B_b Q2 vdd vdd pfet_03v3 L=0.28u W=0.80u nf=1
x_nor_dq5_x2_M6 x_nor_dq5_B_b Q2 vss vss nfet_03v3 L=0.28u W=0.42u nf=1
x_nor_dq5_x3_M2 x_nor_dq5_x3_net1 x_nor_dq5_B_b vss vss nfet_03v3 L=0.28u W=0.50u nf=1
x_nor_dq5_x3_M3 x_nor_dq5_net1 x_nor_dq5_A_b vdd vdd pfet_03v3 L=0.28u W=1.0u nf=1
x_nor_dq5_x3_M1 x_nor_dq5_net1 x_nor_dq5_B_b vdd vdd pfet_03v3 L=0.28u W=1.0u nf=1
x_nor_dq5_x3_M4 x_nor_dq5_net1 x_nor_dq5_A_b x_nor_dq5_x3_net1 vss nfet_03v3 L=0.28u W=0.50u nf=1
x_nor_dq5_x4_M5 dac_n5 x_nor_dq5_net1 vdd vdd pfet_03v3 L=0.28u W=0.80u nf=1
x_nor_dq5_x4_M6 dac_n5 x_nor_dq5_net1 vss vss nfet_03v3 L=0.28u W=0.42u nf=1
x_nor_st5_x1_M5 x_nor_st5_A_b dac_n5 vdd vdd pfet_03v3 L=0.28u W=0.80u nf=1
x_nor_st5_x1_M6 x_nor_st5_A_b dac_n5 vss vss nfet_03v3 L=0.28u W=0.42u nf=1
x_nor_st5_x2_M5 x_nor_st5_B_b start vdd vdd pfet_03v3 L=0.28u W=0.80u nf=1
x_nor_st5_x2_M6 x_nor_st5_B_b start vss vss nfet_03v3 L=0.28u W=0.42u nf=1
x_nor_st5_x3_M2 x_nor_st5_x3_net1 x_nor_st5_B_b vss vss nfet_03v3 L=0.28u W=0.50u nf=1
x_nor_st5_x3_M3 x_nor_st5_net1 x_nor_st5_A_b vdd vdd pfet_03v3 L=0.28u W=1.0u nf=1
x_nor_st5_x3_M1 x_nor_st5_net1 x_nor_st5_B_b vdd vdd pfet_03v3 L=0.28u W=1.0u nf=1
x_nor_st5_x3_M4 x_nor_st5_net1 x_nor_st5_A_b x_nor_st5_x3_net1 vss nfet_03v3 L=0.28u W=0.50u nf=1
x_nor_st5_x4_M5 dac_in[5] x_nor_st5_net1 vdd vdd pfet_03v3 L=0.28u W=0.80u nf=1
x_nor_st5_x4_M6 dac_in[5] x_nor_st5_net1 vss vss nfet_03v3 L=0.28u W=0.42u nf=1
x_bit4_x_nand_set_M2 x_bit4_x_nand_set_net1 Q3 vss vss nfet_03v3 L=0.28u W=0.50u nf=1
x_bit4_x_nand_set_M3 x_bit4_set_n comp_out_p vdd vdd pfet_03v3 L=0.28u W=1.0u nf=1
x_bit4_x_nand_set_M1 x_bit4_set_n Q3 vdd vdd pfet_03v3 L=0.28u W=1.0u nf=1
x_bit4_x_nand_set_M4 x_bit4_set_n comp_out_p x_bit4_x_nand_set_net1 vss nfet_03v3 L=0.28u W=0.50u nf=1
x_bit4_x_inv_set_M5 x_bit4_set x_bit4_set_n vdd vdd pfet_03v3 L=0.28u W=0.80u nf=1
x_bit4_x_inv_set_M6 x_bit4_set x_bit4_set_n vss vss nfet_03v3 L=0.28u W=0.42u nf=1
x_bit4_x_inv_rst_M5 x_bit4_rst rst_n_int vdd vdd pfet_03v3 L=0.28u W=0.80u nf=1
x_bit4_x_inv_rst_M6 x_bit4_rst rst_n_int vss vss nfet_03v3 L=0.28u W=0.42u nf=1
x_bit4_x_nor_q_x1_M5 x_bit4_x_nor_q_A_b x_bit4_rst vdd vdd pfet_03v3 L=0.28u W=0.80u nf=1
x_bit4_x_nor_q_x1_M6 x_bit4_x_nor_q_A_b x_bit4_rst vss vss nfet_03v3 L=0.28u W=0.42u nf=1
x_bit4_x_nor_q_x2_M5 x_bit4_x_nor_q_B_b x_bit4_bit_out_bar vdd vdd pfet_03v3 L=0.28u W=0.80u nf=1
x_bit4_x_nor_q_x2_M6 x_bit4_x_nor_q_B_b x_bit4_bit_out_bar vss vss nfet_03v3 L=0.28u W=0.42u nf=1
x_bit4_x_nor_q_x3_M2 x_bit4_x_nor_q_x3_net1 x_bit4_x_nor_q_B_b vss vss nfet_03v3 L=0.28u W=0.50u nf=1
x_bit4_x_nor_q_x3_M3 x_bit4_x_nor_q_net1 x_bit4_x_nor_q_A_b vdd vdd pfet_03v3 L=0.28u W=1.0u nf=1
x_bit4_x_nor_q_x3_M1 x_bit4_x_nor_q_net1 x_bit4_x_nor_q_B_b vdd vdd pfet_03v3 L=0.28u W=1.0u nf=1
x_bit4_x_nor_q_x3_M4 x_bit4_x_nor_q_net1 x_bit4_x_nor_q_A_b x_bit4_x_nor_q_x3_net1 vss nfet_03v3 L=0.28u W=0.50u nf=1
x_bit4_x_nor_q_x4_M5 dout[4] x_bit4_x_nor_q_net1 vdd vdd pfet_03v3 L=0.28u W=0.80u nf=1
x_bit4_x_nor_q_x4_M6 dout[4] x_bit4_x_nor_q_net1 vss vss nfet_03v3 L=0.28u W=0.42u nf=1
x_bit4_x_nor_qb_x1_M5 x_bit4_x_nor_qb_A_b x_bit4_set vdd vdd pfet_03v3 L=0.28u W=0.80u nf=1
x_bit4_x_nor_qb_x1_M6 x_bit4_x_nor_qb_A_b x_bit4_set vss vss nfet_03v3 L=0.28u W=0.42u nf=1
x_bit4_x_nor_qb_x2_M5 x_bit4_x_nor_qb_B_b dout[4] vdd vdd pfet_03v3 L=0.28u W=0.80u nf=1
x_bit4_x_nor_qb_x2_M6 x_bit4_x_nor_qb_B_b dout[4] vss vss nfet_03v3 L=0.28u W=0.42u nf=1
x_bit4_x_nor_qb_x3_M2 x_bit4_x_nor_qb_x3_net1 x_bit4_x_nor_qb_B_b vss vss nfet_03v3 L=0.28u W=0.50u nf=1
x_bit4_x_nor_qb_x3_M3 x_bit4_x_nor_qb_net1 x_bit4_x_nor_qb_A_b vdd vdd pfet_03v3 L=0.28u W=1.0u nf=1
x_bit4_x_nor_qb_x3_M1 x_bit4_x_nor_qb_net1 x_bit4_x_nor_qb_B_b vdd vdd pfet_03v3 L=0.28u W=1.0u nf=1
x_bit4_x_nor_qb_x3_M4 x_bit4_x_nor_qb_net1 x_bit4_x_nor_qb_A_b x_bit4_x_nor_qb_x3_net1 vss nfet_03v3 L=0.28u W=0.50u nf=1
x_bit4_x_nor_qb_x4_M5 x_bit4_bit_out_bar x_bit4_x_nor_qb_net1 vdd vdd pfet_03v3 L=0.28u W=0.80u nf=1
x_bit4_x_nor_qb_x4_M6 x_bit4_bit_out_bar x_bit4_x_nor_qb_net1 vss vss nfet_03v3 L=0.28u W=0.42u nf=1
x_nor_dq4_x1_M5 x_nor_dq4_A_b dout[4] vdd vdd pfet_03v3 L=0.28u W=0.80u nf=1
x_nor_dq4_x1_M6 x_nor_dq4_A_b dout[4] vss vss nfet_03v3 L=0.28u W=0.42u nf=1
x_nor_dq4_x2_M5 x_nor_dq4_B_b Q3 vdd vdd pfet_03v3 L=0.28u W=0.80u nf=1
x_nor_dq4_x2_M6 x_nor_dq4_B_b Q3 vss vss nfet_03v3 L=0.28u W=0.42u nf=1
x_nor_dq4_x3_M2 x_nor_dq4_x3_net1 x_nor_dq4_B_b vss vss nfet_03v3 L=0.28u W=0.50u nf=1
x_nor_dq4_x3_M3 x_nor_dq4_net1 x_nor_dq4_A_b vdd vdd pfet_03v3 L=0.28u W=1.0u nf=1
x_nor_dq4_x3_M1 x_nor_dq4_net1 x_nor_dq4_B_b vdd vdd pfet_03v3 L=0.28u W=1.0u nf=1
x_nor_dq4_x3_M4 x_nor_dq4_net1 x_nor_dq4_A_b x_nor_dq4_x3_net1 vss nfet_03v3 L=0.28u W=0.50u nf=1
x_nor_dq4_x4_M5 dac_n4 x_nor_dq4_net1 vdd vdd pfet_03v3 L=0.28u W=0.80u nf=1
x_nor_dq4_x4_M6 dac_n4 x_nor_dq4_net1 vss vss nfet_03v3 L=0.28u W=0.42u nf=1
x_nor_st4_x1_M5 x_nor_st4_A_b dac_n4 vdd vdd pfet_03v3 L=0.28u W=0.80u nf=1
x_nor_st4_x1_M6 x_nor_st4_A_b dac_n4 vss vss nfet_03v3 L=0.28u W=0.42u nf=1
x_nor_st4_x2_M5 x_nor_st4_B_b start vdd vdd pfet_03v3 L=0.28u W=0.80u nf=1
x_nor_st4_x2_M6 x_nor_st4_B_b start vss vss nfet_03v3 L=0.28u W=0.42u nf=1
x_nor_st4_x3_M2 x_nor_st4_x3_net1 x_nor_st4_B_b vss vss nfet_03v3 L=0.28u W=0.50u nf=1
x_nor_st4_x3_M3 x_nor_st4_net1 x_nor_st4_A_b vdd vdd pfet_03v3 L=0.28u W=1.0u nf=1
x_nor_st4_x3_M1 x_nor_st4_net1 x_nor_st4_B_b vdd vdd pfet_03v3 L=0.28u W=1.0u nf=1
x_nor_st4_x3_M4 x_nor_st4_net1 x_nor_st4_A_b x_nor_st4_x3_net1 vss nfet_03v3 L=0.28u W=0.50u nf=1
x_nor_st4_x4_M5 dac_in[4] x_nor_st4_net1 vdd vdd pfet_03v3 L=0.28u W=0.80u nf=1
x_nor_st4_x4_M6 dac_in[4] x_nor_st4_net1 vss vss nfet_03v3 L=0.28u W=0.42u nf=1
x_bit3_x_nand_set_M2 x_bit3_x_nand_set_net1 Q4 vss vss nfet_03v3 L=0.28u W=0.50u nf=1
x_bit3_x_nand_set_M3 x_bit3_set_n comp_out_p vdd vdd pfet_03v3 L=0.28u W=1.0u nf=1
x_bit3_x_nand_set_M1 x_bit3_set_n Q4 vdd vdd pfet_03v3 L=0.28u W=1.0u nf=1
x_bit3_x_nand_set_M4 x_bit3_set_n comp_out_p x_bit3_x_nand_set_net1 vss nfet_03v3 L=0.28u W=0.50u nf=1
x_bit3_x_inv_set_M5 x_bit3_set x_bit3_set_n vdd vdd pfet_03v3 L=0.28u W=0.80u nf=1
x_bit3_x_inv_set_M6 x_bit3_set x_bit3_set_n vss vss nfet_03v3 L=0.28u W=0.42u nf=1
x_bit3_x_inv_rst_M5 x_bit3_rst rst_n_int vdd vdd pfet_03v3 L=0.28u W=0.80u nf=1
x_bit3_x_inv_rst_M6 x_bit3_rst rst_n_int vss vss nfet_03v3 L=0.28u W=0.42u nf=1
x_bit3_x_nor_q_x1_M5 x_bit3_x_nor_q_A_b x_bit3_rst vdd vdd pfet_03v3 L=0.28u W=0.80u nf=1
x_bit3_x_nor_q_x1_M6 x_bit3_x_nor_q_A_b x_bit3_rst vss vss nfet_03v3 L=0.28u W=0.42u nf=1
x_bit3_x_nor_q_x2_M5 x_bit3_x_nor_q_B_b x_bit3_bit_out_bar vdd vdd pfet_03v3 L=0.28u W=0.80u nf=1
x_bit3_x_nor_q_x2_M6 x_bit3_x_nor_q_B_b x_bit3_bit_out_bar vss vss nfet_03v3 L=0.28u W=0.42u nf=1
x_bit3_x_nor_q_x3_M2 x_bit3_x_nor_q_x3_net1 x_bit3_x_nor_q_B_b vss vss nfet_03v3 L=0.28u W=0.50u nf=1
x_bit3_x_nor_q_x3_M3 x_bit3_x_nor_q_net1 x_bit3_x_nor_q_A_b vdd vdd pfet_03v3 L=0.28u W=1.0u nf=1
x_bit3_x_nor_q_x3_M1 x_bit3_x_nor_q_net1 x_bit3_x_nor_q_B_b vdd vdd pfet_03v3 L=0.28u W=1.0u nf=1
x_bit3_x_nor_q_x3_M4 x_bit3_x_nor_q_net1 x_bit3_x_nor_q_A_b x_bit3_x_nor_q_x3_net1 vss nfet_03v3 L=0.28u W=0.50u nf=1
x_bit3_x_nor_q_x4_M5 dout[3] x_bit3_x_nor_q_net1 vdd vdd pfet_03v3 L=0.28u W=0.80u nf=1
x_bit3_x_nor_q_x4_M6 dout[3] x_bit3_x_nor_q_net1 vss vss nfet_03v3 L=0.28u W=0.42u nf=1
x_bit3_x_nor_qb_x1_M5 x_bit3_x_nor_qb_A_b x_bit3_set vdd vdd pfet_03v3 L=0.28u W=0.80u nf=1
x_bit3_x_nor_qb_x1_M6 x_bit3_x_nor_qb_A_b x_bit3_set vss vss nfet_03v3 L=0.28u W=0.42u nf=1
x_bit3_x_nor_qb_x2_M5 x_bit3_x_nor_qb_B_b dout[3] vdd vdd pfet_03v3 L=0.28u W=0.80u nf=1
x_bit3_x_nor_qb_x2_M6 x_bit3_x_nor_qb_B_b dout[3] vss vss nfet_03v3 L=0.28u W=0.42u nf=1
x_bit3_x_nor_qb_x3_M2 x_bit3_x_nor_qb_x3_net1 x_bit3_x_nor_qb_B_b vss vss nfet_03v3 L=0.28u W=0.50u nf=1
x_bit3_x_nor_qb_x3_M3 x_bit3_x_nor_qb_net1 x_bit3_x_nor_qb_A_b vdd vdd pfet_03v3 L=0.28u W=1.0u nf=1
x_bit3_x_nor_qb_x3_M1 x_bit3_x_nor_qb_net1 x_bit3_x_nor_qb_B_b vdd vdd pfet_03v3 L=0.28u W=1.0u nf=1
x_bit3_x_nor_qb_x3_M4 x_bit3_x_nor_qb_net1 x_bit3_x_nor_qb_A_b x_bit3_x_nor_qb_x3_net1 vss nfet_03v3 L=0.28u W=0.50u nf=1
x_bit3_x_nor_qb_x4_M5 x_bit3_bit_out_bar x_bit3_x_nor_qb_net1 vdd vdd pfet_03v3 L=0.28u W=0.80u nf=1
x_bit3_x_nor_qb_x4_M6 x_bit3_bit_out_bar x_bit3_x_nor_qb_net1 vss vss nfet_03v3 L=0.28u W=0.42u nf=1
x_nor_dq3_x1_M5 x_nor_dq3_A_b dout[3] vdd vdd pfet_03v3 L=0.28u W=0.80u nf=1
x_nor_dq3_x1_M6 x_nor_dq3_A_b dout[3] vss vss nfet_03v3 L=0.28u W=0.42u nf=1
x_nor_dq3_x2_M5 x_nor_dq3_B_b Q4 vdd vdd pfet_03v3 L=0.28u W=0.80u nf=1
x_nor_dq3_x2_M6 x_nor_dq3_B_b Q4 vss vss nfet_03v3 L=0.28u W=0.42u nf=1
x_nor_dq3_x3_M2 x_nor_dq3_x3_net1 x_nor_dq3_B_b vss vss nfet_03v3 L=0.28u W=0.50u nf=1
x_nor_dq3_x3_M3 x_nor_dq3_net1 x_nor_dq3_A_b vdd vdd pfet_03v3 L=0.28u W=1.0u nf=1
x_nor_dq3_x3_M1 x_nor_dq3_net1 x_nor_dq3_B_b vdd vdd pfet_03v3 L=0.28u W=1.0u nf=1
x_nor_dq3_x3_M4 x_nor_dq3_net1 x_nor_dq3_A_b x_nor_dq3_x3_net1 vss nfet_03v3 L=0.28u W=0.50u nf=1
x_nor_dq3_x4_M5 dac_n3 x_nor_dq3_net1 vdd vdd pfet_03v3 L=0.28u W=0.80u nf=1
x_nor_dq3_x4_M6 dac_n3 x_nor_dq3_net1 vss vss nfet_03v3 L=0.28u W=0.42u nf=1
x_nor_st3_x1_M5 x_nor_st3_A_b dac_n3 vdd vdd pfet_03v3 L=0.28u W=0.80u nf=1
x_nor_st3_x1_M6 x_nor_st3_A_b dac_n3 vss vss nfet_03v3 L=0.28u W=0.42u nf=1
x_nor_st3_x2_M5 x_nor_st3_B_b start vdd vdd pfet_03v3 L=0.28u W=0.80u nf=1
x_nor_st3_x2_M6 x_nor_st3_B_b start vss vss nfet_03v3 L=0.28u W=0.42u nf=1
x_nor_st3_x3_M2 x_nor_st3_x3_net1 x_nor_st3_B_b vss vss nfet_03v3 L=0.28u W=0.50u nf=1
x_nor_st3_x3_M3 x_nor_st3_net1 x_nor_st3_A_b vdd vdd pfet_03v3 L=0.28u W=1.0u nf=1
x_nor_st3_x3_M1 x_nor_st3_net1 x_nor_st3_B_b vdd vdd pfet_03v3 L=0.28u W=1.0u nf=1
x_nor_st3_x3_M4 x_nor_st3_net1 x_nor_st3_A_b x_nor_st3_x3_net1 vss nfet_03v3 L=0.28u W=0.50u nf=1
x_nor_st3_x4_M5 dac_in[3] x_nor_st3_net1 vdd vdd pfet_03v3 L=0.28u W=0.80u nf=1
x_nor_st3_x4_M6 dac_in[3] x_nor_st3_net1 vss vss nfet_03v3 L=0.28u W=0.42u nf=1
x_bit2_x_nand_set_M2 x_bit2_x_nand_set_net1 Q5 vss vss nfet_03v3 L=0.28u W=0.50u nf=1
x_bit2_x_nand_set_M3 x_bit2_set_n comp_out_p vdd vdd pfet_03v3 L=0.28u W=1.0u nf=1
x_bit2_x_nand_set_M1 x_bit2_set_n Q5 vdd vdd pfet_03v3 L=0.28u W=1.0u nf=1
x_bit2_x_nand_set_M4 x_bit2_set_n comp_out_p x_bit2_x_nand_set_net1 vss nfet_03v3 L=0.28u W=0.50u nf=1
x_bit2_x_inv_set_M5 x_bit2_set x_bit2_set_n vdd vdd pfet_03v3 L=0.28u W=0.80u nf=1
x_bit2_x_inv_set_M6 x_bit2_set x_bit2_set_n vss vss nfet_03v3 L=0.28u W=0.42u nf=1
x_bit2_x_inv_rst_M5 x_bit2_rst rst_n_int vdd vdd pfet_03v3 L=0.28u W=0.80u nf=1
x_bit2_x_inv_rst_M6 x_bit2_rst rst_n_int vss vss nfet_03v3 L=0.28u W=0.42u nf=1
x_bit2_x_nor_q_x1_M5 x_bit2_x_nor_q_A_b x_bit2_rst vdd vdd pfet_03v3 L=0.28u W=0.80u nf=1
x_bit2_x_nor_q_x1_M6 x_bit2_x_nor_q_A_b x_bit2_rst vss vss nfet_03v3 L=0.28u W=0.42u nf=1
x_bit2_x_nor_q_x2_M5 x_bit2_x_nor_q_B_b x_bit2_bit_out_bar vdd vdd pfet_03v3 L=0.28u W=0.80u nf=1
x_bit2_x_nor_q_x2_M6 x_bit2_x_nor_q_B_b x_bit2_bit_out_bar vss vss nfet_03v3 L=0.28u W=0.42u nf=1
x_bit2_x_nor_q_x3_M2 x_bit2_x_nor_q_x3_net1 x_bit2_x_nor_q_B_b vss vss nfet_03v3 L=0.28u W=0.50u nf=1
x_bit2_x_nor_q_x3_M3 x_bit2_x_nor_q_net1 x_bit2_x_nor_q_A_b vdd vdd pfet_03v3 L=0.28u W=1.0u nf=1
x_bit2_x_nor_q_x3_M1 x_bit2_x_nor_q_net1 x_bit2_x_nor_q_B_b vdd vdd pfet_03v3 L=0.28u W=1.0u nf=1
x_bit2_x_nor_q_x3_M4 x_bit2_x_nor_q_net1 x_bit2_x_nor_q_A_b x_bit2_x_nor_q_x3_net1 vss nfet_03v3 L=0.28u W=0.50u nf=1
x_bit2_x_nor_q_x4_M5 dout[2] x_bit2_x_nor_q_net1 vdd vdd pfet_03v3 L=0.28u W=0.80u nf=1
x_bit2_x_nor_q_x4_M6 dout[2] x_bit2_x_nor_q_net1 vss vss nfet_03v3 L=0.28u W=0.42u nf=1
x_bit2_x_nor_qb_x1_M5 x_bit2_x_nor_qb_A_b x_bit2_set vdd vdd pfet_03v3 L=0.28u W=0.80u nf=1
x_bit2_x_nor_qb_x1_M6 x_bit2_x_nor_qb_A_b x_bit2_set vss vss nfet_03v3 L=0.28u W=0.42u nf=1
x_bit2_x_nor_qb_x2_M5 x_bit2_x_nor_qb_B_b dout[2] vdd vdd pfet_03v3 L=0.28u W=0.80u nf=1
x_bit2_x_nor_qb_x2_M6 x_bit2_x_nor_qb_B_b dout[2] vss vss nfet_03v3 L=0.28u W=0.42u nf=1
x_bit2_x_nor_qb_x3_M2 x_bit2_x_nor_qb_x3_net1 x_bit2_x_nor_qb_B_b vss vss nfet_03v3 L=0.28u W=0.50u nf=1
x_bit2_x_nor_qb_x3_M3 x_bit2_x_nor_qb_net1 x_bit2_x_nor_qb_A_b vdd vdd pfet_03v3 L=0.28u W=1.0u nf=1
x_bit2_x_nor_qb_x3_M1 x_bit2_x_nor_qb_net1 x_bit2_x_nor_qb_B_b vdd vdd pfet_03v3 L=0.28u W=1.0u nf=1
x_bit2_x_nor_qb_x3_M4 x_bit2_x_nor_qb_net1 x_bit2_x_nor_qb_A_b x_bit2_x_nor_qb_x3_net1 vss nfet_03v3 L=0.28u W=0.50u nf=1
x_bit2_x_nor_qb_x4_M5 x_bit2_bit_out_bar x_bit2_x_nor_qb_net1 vdd vdd pfet_03v3 L=0.28u W=0.80u nf=1
x_bit2_x_nor_qb_x4_M6 x_bit2_bit_out_bar x_bit2_x_nor_qb_net1 vss vss nfet_03v3 L=0.28u W=0.42u nf=1
x_nor_dq2_x1_M5 x_nor_dq2_A_b dout[2] vdd vdd pfet_03v3 L=0.28u W=0.80u nf=1
x_nor_dq2_x1_M6 x_nor_dq2_A_b dout[2] vss vss nfet_03v3 L=0.28u W=0.42u nf=1
x_nor_dq2_x2_M5 x_nor_dq2_B_b Q5 vdd vdd pfet_03v3 L=0.28u W=0.80u nf=1
x_nor_dq2_x2_M6 x_nor_dq2_B_b Q5 vss vss nfet_03v3 L=0.28u W=0.42u nf=1
x_nor_dq2_x3_M2 x_nor_dq2_x3_net1 x_nor_dq2_B_b vss vss nfet_03v3 L=0.28u W=0.50u nf=1
x_nor_dq2_x3_M3 x_nor_dq2_net1 x_nor_dq2_A_b vdd vdd pfet_03v3 L=0.28u W=1.0u nf=1
x_nor_dq2_x3_M1 x_nor_dq2_net1 x_nor_dq2_B_b vdd vdd pfet_03v3 L=0.28u W=1.0u nf=1
x_nor_dq2_x3_M4 x_nor_dq2_net1 x_nor_dq2_A_b x_nor_dq2_x3_net1 vss nfet_03v3 L=0.28u W=0.50u nf=1
x_nor_dq2_x4_M5 dac_n2 x_nor_dq2_net1 vdd vdd pfet_03v3 L=0.28u W=0.80u nf=1
x_nor_dq2_x4_M6 dac_n2 x_nor_dq2_net1 vss vss nfet_03v3 L=0.28u W=0.42u nf=1
x_nor_st2_x1_M5 x_nor_st2_A_b dac_n2 vdd vdd pfet_03v3 L=0.28u W=0.80u nf=1
x_nor_st2_x1_M6 x_nor_st2_A_b dac_n2 vss vss nfet_03v3 L=0.28u W=0.42u nf=1
x_nor_st2_x2_M5 x_nor_st2_B_b start vdd vdd pfet_03v3 L=0.28u W=0.80u nf=1
x_nor_st2_x2_M6 x_nor_st2_B_b start vss vss nfet_03v3 L=0.28u W=0.42u nf=1
x_nor_st2_x3_M2 x_nor_st2_x3_net1 x_nor_st2_B_b vss vss nfet_03v3 L=0.28u W=0.50u nf=1
x_nor_st2_x3_M3 x_nor_st2_net1 x_nor_st2_A_b vdd vdd pfet_03v3 L=0.28u W=1.0u nf=1
x_nor_st2_x3_M1 x_nor_st2_net1 x_nor_st2_B_b vdd vdd pfet_03v3 L=0.28u W=1.0u nf=1
x_nor_st2_x3_M4 x_nor_st2_net1 x_nor_st2_A_b x_nor_st2_x3_net1 vss nfet_03v3 L=0.28u W=0.50u nf=1
x_nor_st2_x4_M5 dac_in[2] x_nor_st2_net1 vdd vdd pfet_03v3 L=0.28u W=0.80u nf=1
x_nor_st2_x4_M6 dac_in[2] x_nor_st2_net1 vss vss nfet_03v3 L=0.28u W=0.42u nf=1
x_bit1_x_nand_set_M2 x_bit1_x_nand_set_net1 Q6 vss vss nfet_03v3 L=0.28u W=0.50u nf=1
x_bit1_x_nand_set_M3 x_bit1_set_n comp_out_p vdd vdd pfet_03v3 L=0.28u W=1.0u nf=1
x_bit1_x_nand_set_M1 x_bit1_set_n Q6 vdd vdd pfet_03v3 L=0.28u W=1.0u nf=1
x_bit1_x_nand_set_M4 x_bit1_set_n comp_out_p x_bit1_x_nand_set_net1 vss nfet_03v3 L=0.28u W=0.50u nf=1
x_bit1_x_inv_set_M5 x_bit1_set x_bit1_set_n vdd vdd pfet_03v3 L=0.28u W=0.80u nf=1
x_bit1_x_inv_set_M6 x_bit1_set x_bit1_set_n vss vss nfet_03v3 L=0.28u W=0.42u nf=1
x_bit1_x_inv_rst_M5 x_bit1_rst rst_n_int vdd vdd pfet_03v3 L=0.28u W=0.80u nf=1
x_bit1_x_inv_rst_M6 x_bit1_rst rst_n_int vss vss nfet_03v3 L=0.28u W=0.42u nf=1
x_bit1_x_nor_q_x1_M5 x_bit1_x_nor_q_A_b x_bit1_rst vdd vdd pfet_03v3 L=0.28u W=0.80u nf=1
x_bit1_x_nor_q_x1_M6 x_bit1_x_nor_q_A_b x_bit1_rst vss vss nfet_03v3 L=0.28u W=0.42u nf=1
x_bit1_x_nor_q_x2_M5 x_bit1_x_nor_q_B_b x_bit1_bit_out_bar vdd vdd pfet_03v3 L=0.28u W=0.80u nf=1
x_bit1_x_nor_q_x2_M6 x_bit1_x_nor_q_B_b x_bit1_bit_out_bar vss vss nfet_03v3 L=0.28u W=0.42u nf=1
x_bit1_x_nor_q_x3_M2 x_bit1_x_nor_q_x3_net1 x_bit1_x_nor_q_B_b vss vss nfet_03v3 L=0.28u W=0.50u nf=1
x_bit1_x_nor_q_x3_M3 x_bit1_x_nor_q_net1 x_bit1_x_nor_q_A_b vdd vdd pfet_03v3 L=0.28u W=1.0u nf=1
x_bit1_x_nor_q_x3_M1 x_bit1_x_nor_q_net1 x_bit1_x_nor_q_B_b vdd vdd pfet_03v3 L=0.28u W=1.0u nf=1
x_bit1_x_nor_q_x3_M4 x_bit1_x_nor_q_net1 x_bit1_x_nor_q_A_b x_bit1_x_nor_q_x3_net1 vss nfet_03v3 L=0.28u W=0.50u nf=1
x_bit1_x_nor_q_x4_M5 dout[1] x_bit1_x_nor_q_net1 vdd vdd pfet_03v3 L=0.28u W=0.80u nf=1
x_bit1_x_nor_q_x4_M6 dout[1] x_bit1_x_nor_q_net1 vss vss nfet_03v3 L=0.28u W=0.42u nf=1
x_bit1_x_nor_qb_x1_M5 x_bit1_x_nor_qb_A_b x_bit1_set vdd vdd pfet_03v3 L=0.28u W=0.80u nf=1
x_bit1_x_nor_qb_x1_M6 x_bit1_x_nor_qb_A_b x_bit1_set vss vss nfet_03v3 L=0.28u W=0.42u nf=1
x_bit1_x_nor_qb_x2_M5 x_bit1_x_nor_qb_B_b dout[1] vdd vdd pfet_03v3 L=0.28u W=0.80u nf=1
x_bit1_x_nor_qb_x2_M6 x_bit1_x_nor_qb_B_b dout[1] vss vss nfet_03v3 L=0.28u W=0.42u nf=1
x_bit1_x_nor_qb_x3_M2 x_bit1_x_nor_qb_x3_net1 x_bit1_x_nor_qb_B_b vss vss nfet_03v3 L=0.28u W=0.50u nf=1
x_bit1_x_nor_qb_x3_M3 x_bit1_x_nor_qb_net1 x_bit1_x_nor_qb_A_b vdd vdd pfet_03v3 L=0.28u W=1.0u nf=1
x_bit1_x_nor_qb_x3_M1 x_bit1_x_nor_qb_net1 x_bit1_x_nor_qb_B_b vdd vdd pfet_03v3 L=0.28u W=1.0u nf=1
x_bit1_x_nor_qb_x3_M4 x_bit1_x_nor_qb_net1 x_bit1_x_nor_qb_A_b x_bit1_x_nor_qb_x3_net1 vss nfet_03v3 L=0.28u W=0.50u nf=1
x_bit1_x_nor_qb_x4_M5 x_bit1_bit_out_bar x_bit1_x_nor_qb_net1 vdd vdd pfet_03v3 L=0.28u W=0.80u nf=1
x_bit1_x_nor_qb_x4_M6 x_bit1_bit_out_bar x_bit1_x_nor_qb_net1 vss vss nfet_03v3 L=0.28u W=0.42u nf=1
x_nor_dq1_x1_M5 x_nor_dq1_A_b dout[1] vdd vdd pfet_03v3 L=0.28u W=0.80u nf=1
x_nor_dq1_x1_M6 x_nor_dq1_A_b dout[1] vss vss nfet_03v3 L=0.28u W=0.42u nf=1
x_nor_dq1_x2_M5 x_nor_dq1_B_b Q6 vdd vdd pfet_03v3 L=0.28u W=0.80u nf=1
x_nor_dq1_x2_M6 x_nor_dq1_B_b Q6 vss vss nfet_03v3 L=0.28u W=0.42u nf=1
x_nor_dq1_x3_M2 x_nor_dq1_x3_net1 x_nor_dq1_B_b vss vss nfet_03v3 L=0.28u W=0.50u nf=1
x_nor_dq1_x3_M3 x_nor_dq1_net1 x_nor_dq1_A_b vdd vdd pfet_03v3 L=0.28u W=1.0u nf=1
x_nor_dq1_x3_M1 x_nor_dq1_net1 x_nor_dq1_B_b vdd vdd pfet_03v3 L=0.28u W=1.0u nf=1
x_nor_dq1_x3_M4 x_nor_dq1_net1 x_nor_dq1_A_b x_nor_dq1_x3_net1 vss nfet_03v3 L=0.28u W=0.50u nf=1
x_nor_dq1_x4_M5 dac_n1 x_nor_dq1_net1 vdd vdd pfet_03v3 L=0.28u W=0.80u nf=1
x_nor_dq1_x4_M6 dac_n1 x_nor_dq1_net1 vss vss nfet_03v3 L=0.28u W=0.42u nf=1
x_nor_st1_x1_M5 x_nor_st1_A_b dac_n1 vdd vdd pfet_03v3 L=0.28u W=0.80u nf=1
x_nor_st1_x1_M6 x_nor_st1_A_b dac_n1 vss vss nfet_03v3 L=0.28u W=0.42u nf=1
x_nor_st1_x2_M5 x_nor_st1_B_b start vdd vdd pfet_03v3 L=0.28u W=0.80u nf=1
x_nor_st1_x2_M6 x_nor_st1_B_b start vss vss nfet_03v3 L=0.28u W=0.42u nf=1
x_nor_st1_x3_M2 x_nor_st1_x3_net1 x_nor_st1_B_b vss vss nfet_03v3 L=0.28u W=0.50u nf=1
x_nor_st1_x3_M3 x_nor_st1_net1 x_nor_st1_A_b vdd vdd pfet_03v3 L=0.28u W=1.0u nf=1
x_nor_st1_x3_M1 x_nor_st1_net1 x_nor_st1_B_b vdd vdd pfet_03v3 L=0.28u W=1.0u nf=1
x_nor_st1_x3_M4 x_nor_st1_net1 x_nor_st1_A_b x_nor_st1_x3_net1 vss nfet_03v3 L=0.28u W=0.50u nf=1
x_nor_st1_x4_M5 dac_in[1] x_nor_st1_net1 vdd vdd pfet_03v3 L=0.28u W=0.80u nf=1
x_nor_st1_x4_M6 dac_in[1] x_nor_st1_net1 vss vss nfet_03v3 L=0.28u W=0.42u nf=1
x_bit0_x_nand_set_M2 x_bit0_x_nand_set_net1 Q7 vss vss nfet_03v3 L=0.28u W=0.50u nf=1
x_bit0_x_nand_set_M3 x_bit0_set_n comp_out_p vdd vdd pfet_03v3 L=0.28u W=1.0u nf=1
x_bit0_x_nand_set_M1 x_bit0_set_n Q7 vdd vdd pfet_03v3 L=0.28u W=1.0u nf=1
x_bit0_x_nand_set_M4 x_bit0_set_n comp_out_p x_bit0_x_nand_set_net1 vss nfet_03v3 L=0.28u W=0.50u nf=1
x_bit0_x_inv_set_M5 x_bit0_set x_bit0_set_n vdd vdd pfet_03v3 L=0.28u W=0.80u nf=1
x_bit0_x_inv_set_M6 x_bit0_set x_bit0_set_n vss vss nfet_03v3 L=0.28u W=0.42u nf=1
x_bit0_x_inv_rst_M5 x_bit0_rst rst_n_int vdd vdd pfet_03v3 L=0.28u W=0.80u nf=1
x_bit0_x_inv_rst_M6 x_bit0_rst rst_n_int vss vss nfet_03v3 L=0.28u W=0.42u nf=1
x_bit0_x_nor_q_x1_M5 x_bit0_x_nor_q_A_b x_bit0_rst vdd vdd pfet_03v3 L=0.28u W=0.80u nf=1
x_bit0_x_nor_q_x1_M6 x_bit0_x_nor_q_A_b x_bit0_rst vss vss nfet_03v3 L=0.28u W=0.42u nf=1
x_bit0_x_nor_q_x2_M5 x_bit0_x_nor_q_B_b x_bit0_bit_out_bar vdd vdd pfet_03v3 L=0.28u W=0.80u nf=1
x_bit0_x_nor_q_x2_M6 x_bit0_x_nor_q_B_b x_bit0_bit_out_bar vss vss nfet_03v3 L=0.28u W=0.42u nf=1
x_bit0_x_nor_q_x3_M2 x_bit0_x_nor_q_x3_net1 x_bit0_x_nor_q_B_b vss vss nfet_03v3 L=0.28u W=0.50u nf=1
x_bit0_x_nor_q_x3_M3 x_bit0_x_nor_q_net1 x_bit0_x_nor_q_A_b vdd vdd pfet_03v3 L=0.28u W=1.0u nf=1
x_bit0_x_nor_q_x3_M1 x_bit0_x_nor_q_net1 x_bit0_x_nor_q_B_b vdd vdd pfet_03v3 L=0.28u W=1.0u nf=1
x_bit0_x_nor_q_x3_M4 x_bit0_x_nor_q_net1 x_bit0_x_nor_q_A_b x_bit0_x_nor_q_x3_net1 vss nfet_03v3 L=0.28u W=0.50u nf=1
x_bit0_x_nor_q_x4_M5 dout[0] x_bit0_x_nor_q_net1 vdd vdd pfet_03v3 L=0.28u W=0.80u nf=1
x_bit0_x_nor_q_x4_M6 dout[0] x_bit0_x_nor_q_net1 vss vss nfet_03v3 L=0.28u W=0.42u nf=1
x_bit0_x_nor_qb_x1_M5 x_bit0_x_nor_qb_A_b x_bit0_set vdd vdd pfet_03v3 L=0.28u W=0.80u nf=1
x_bit0_x_nor_qb_x1_M6 x_bit0_x_nor_qb_A_b x_bit0_set vss vss nfet_03v3 L=0.28u W=0.42u nf=1
x_bit0_x_nor_qb_x2_M5 x_bit0_x_nor_qb_B_b dout[0] vdd vdd pfet_03v3 L=0.28u W=0.80u nf=1
x_bit0_x_nor_qb_x2_M6 x_bit0_x_nor_qb_B_b dout[0] vss vss nfet_03v3 L=0.28u W=0.42u nf=1
x_bit0_x_nor_qb_x3_M2 x_bit0_x_nor_qb_x3_net1 x_bit0_x_nor_qb_B_b vss vss nfet_03v3 L=0.28u W=0.50u nf=1
x_bit0_x_nor_qb_x3_M3 x_bit0_x_nor_qb_net1 x_bit0_x_nor_qb_A_b vdd vdd pfet_03v3 L=0.28u W=1.0u nf=1
x_bit0_x_nor_qb_x3_M1 x_bit0_x_nor_qb_net1 x_bit0_x_nor_qb_B_b vdd vdd pfet_03v3 L=0.28u W=1.0u nf=1
x_bit0_x_nor_qb_x3_M4 x_bit0_x_nor_qb_net1 x_bit0_x_nor_qb_A_b x_bit0_x_nor_qb_x3_net1 vss nfet_03v3 L=0.28u W=0.50u nf=1
x_bit0_x_nor_qb_x4_M5 x_bit0_bit_out_bar x_bit0_x_nor_qb_net1 vdd vdd pfet_03v3 L=0.28u W=0.80u nf=1
x_bit0_x_nor_qb_x4_M6 x_bit0_bit_out_bar x_bit0_x_nor_qb_net1 vss vss nfet_03v3 L=0.28u W=0.42u nf=1
x_nor_dq0_x1_M5 x_nor_dq0_A_b dout[0] vdd vdd pfet_03v3 L=0.28u W=0.80u nf=1
x_nor_dq0_x1_M6 x_nor_dq0_A_b dout[0] vss vss nfet_03v3 L=0.28u W=0.42u nf=1
x_nor_dq0_x2_M5 x_nor_dq0_B_b Q7 vdd vdd pfet_03v3 L=0.28u W=0.80u nf=1
x_nor_dq0_x2_M6 x_nor_dq0_B_b Q7 vss vss nfet_03v3 L=0.28u W=0.42u nf=1
x_nor_dq0_x3_M2 x_nor_dq0_x3_net1 x_nor_dq0_B_b vss vss nfet_03v3 L=0.28u W=0.50u nf=1
x_nor_dq0_x3_M3 x_nor_dq0_net1 x_nor_dq0_A_b vdd vdd pfet_03v3 L=0.28u W=1.0u nf=1
x_nor_dq0_x3_M1 x_nor_dq0_net1 x_nor_dq0_B_b vdd vdd pfet_03v3 L=0.28u W=1.0u nf=1
x_nor_dq0_x3_M4 x_nor_dq0_net1 x_nor_dq0_A_b x_nor_dq0_x3_net1 vss nfet_03v3 L=0.28u W=0.50u nf=1
x_nor_dq0_x4_M5 dac_n0 x_nor_dq0_net1 vdd vdd pfet_03v3 L=0.28u W=0.80u nf=1
x_nor_dq0_x4_M6 dac_n0 x_nor_dq0_net1 vss vss nfet_03v3 L=0.28u W=0.42u nf=1
x_nor_st0_x1_M5 x_nor_st0_A_b dac_n0 vdd vdd pfet_03v3 L=0.28u W=0.80u nf=1
x_nor_st0_x1_M6 x_nor_st0_A_b dac_n0 vss vss nfet_03v3 L=0.28u W=0.42u nf=1
x_nor_st0_x2_M5 x_nor_st0_B_b start vdd vdd pfet_03v3 L=0.28u W=0.80u nf=1
x_nor_st0_x2_M6 x_nor_st0_B_b start vss vss nfet_03v3 L=0.28u W=0.42u nf=1
x_nor_st0_x3_M2 x_nor_st0_x3_net1 x_nor_st0_B_b vss vss nfet_03v3 L=0.28u W=0.50u nf=1
x_nor_st0_x3_M3 x_nor_st0_net1 x_nor_st0_A_b vdd vdd pfet_03v3 L=0.28u W=1.0u nf=1
x_nor_st0_x3_M1 x_nor_st0_net1 x_nor_st0_B_b vdd vdd pfet_03v3 L=0.28u W=1.0u nf=1
x_nor_st0_x3_M4 x_nor_st0_net1 x_nor_st0_A_b x_nor_st0_x3_net1 vss nfet_03v3 L=0.28u W=0.50u nf=1
x_nor_st0_x4_M5 dac_in[0] x_nor_st0_net1 vdd vdd pfet_03v3 L=0.28u W=0.80u nf=1
x_nor_st0_x4_M6 dac_in[0] x_nor_st0_net1 vss vss nfet_03v3 L=0.28u W=0.42u nf=1
x_inv_cd_M5 comp_done_inv comp_done vdd vdd pfet_03v3 L=0.28u W=0.80u nf=1
x_inv_cd_M6 comp_done_inv comp_done vss vss nfet_03v3 L=0.28u W=0.42u nf=1
x_del_x1_M5 x_del_net1 comp_done vdd vdd pfet_03v3 L=0.28u W=0.80u nf=1
x_del_x1_M6 x_del_net1 comp_done vss vss nfet_03v3 L=0.28u W=0.42u nf=1
x_del_x2_M5 x_del_net2 x_del_net1 vdd vdd pfet_03v3 L=0.28u W=0.80u nf=1
x_del_x2_M6 x_del_net2 x_del_net1 vss vss nfet_03v3 L=0.28u W=0.42u nf=1
x_del_x3_M5 x_del_net3 x_del_net2 vdd vdd pfet_03v3 L=0.28u W=0.80u nf=1
x_del_x3_M6 x_del_net3 x_del_net2 vss vss nfet_03v3 L=0.28u W=0.42u nf=1
x_del_x4_M5 x_del_net4 x_del_net3 vdd vdd pfet_03v3 L=0.28u W=0.80u nf=1
x_del_x4_M6 x_del_net4 x_del_net3 vss vss nfet_03v3 L=0.28u W=0.42u nf=1
x_del_x5_M5 x_del_net5 x_del_net4 vdd vdd pfet_03v3 L=0.28u W=0.80u nf=1
x_del_x5_M6 x_del_net5 x_del_net4 vss vss nfet_03v3 L=0.28u W=0.42u nf=1
x_del_x6_M5 x_del_net6 x_del_net5 vdd vdd pfet_03v3 L=0.28u W=0.80u nf=1
x_del_x6_M6 x_del_net6 x_del_net5 vss vss nfet_03v3 L=0.28u W=0.42u nf=1
x_del_x7_M5 x_del_net7 x_del_net6 vdd vdd pfet_03v3 L=0.28u W=0.80u nf=1
x_del_x7_M6 x_del_net7 x_del_net6 vss vss nfet_03v3 L=0.28u W=0.42u nf=1
x_del_x8_M5 x_del_net8 x_del_net7 vdd vdd pfet_03v3 L=0.28u W=0.80u nf=1
x_del_x8_M6 x_del_net8 x_del_net7 vss vss nfet_03v3 L=0.28u W=0.42u nf=1
x_del_x9_M5 x_del_net9 x_del_net8 vdd vdd pfet_03v3 L=0.28u W=0.80u nf=1
x_del_x9_M6 x_del_net9 x_del_net8 vss vss nfet_03v3 L=0.28u W=0.42u nf=1
x_del_x10_M5 x_del_net10 x_del_net9 vdd vdd pfet_03v3 L=0.28u W=0.80u nf=1
x_del_x10_M6 x_del_net10 x_del_net9 vss vss nfet_03v3 L=0.28u W=0.42u nf=1
x_del_x11_M5 x_del_net11 x_del_net10 vdd vdd pfet_03v3 L=0.28u W=0.80u nf=1
x_del_x11_M6 x_del_net11 x_del_net10 vss vss nfet_03v3 L=0.28u W=0.42u nf=1
x_del_x12_M5 x_del_net12 x_del_net11 vdd vdd pfet_03v3 L=0.28u W=0.80u nf=1
x_del_x12_M6 x_del_net12 x_del_net11 vss vss nfet_03v3 L=0.28u W=0.42u nf=1
x_del_x13_M5 x_del_net13 x_del_net12 vdd vdd pfet_03v3 L=0.28u W=0.80u nf=1
x_del_x13_M6 x_del_net13 x_del_net12 vss vss nfet_03v3 L=0.28u W=0.42u nf=1
x_del_x14_M5 x_del_net14 x_del_net13 vdd vdd pfet_03v3 L=0.28u W=0.80u nf=1
x_del_x14_M6 x_del_net14 x_del_net13 vss vss nfet_03v3 L=0.28u W=0.42u nf=1
x_del_x15_M5 x_del_net15 x_del_net14 vdd vdd pfet_03v3 L=0.28u W=0.80u nf=1
x_del_x15_M6 x_del_net15 x_del_net14 vss vss nfet_03v3 L=0.28u W=0.42u nf=1
x_del_x16_M5 x_del_net16 x_del_net15 vdd vdd pfet_03v3 L=0.28u W=0.80u nf=1
x_del_x16_M6 x_del_net16 x_del_net15 vss vss nfet_03v3 L=0.28u W=0.42u nf=1
x_del_x17_M5 x_del_net17 x_del_net16 vdd vdd pfet_03v3 L=0.28u W=0.80u nf=1
x_del_x17_M6 x_del_net17 x_del_net16 vss vss nfet_03v3 L=0.28u W=0.42u nf=1
x_del_x18_M5 x_del_net18 x_del_net17 vdd vdd pfet_03v3 L=0.28u W=0.80u nf=1
x_del_x18_M6 x_del_net18 x_del_net17 vss vss nfet_03v3 L=0.28u W=0.42u nf=1
x_del_x19_M5 x_del_net19 x_del_net18 vdd vdd pfet_03v3 L=0.28u W=0.80u nf=1
x_del_x19_M6 x_del_net19 x_del_net18 vss vss nfet_03v3 L=0.28u W=0.42u nf=1
x_del_x20_M5 x_del_net20 x_del_net19 vdd vdd pfet_03v3 L=0.28u W=0.80u nf=1
x_del_x20_M6 x_del_net20 x_del_net19 vss vss nfet_03v3 L=0.28u W=0.42u nf=1
x_del_x21_M5 comp_done_delayed_n x_del_net20 vdd vdd pfet_03v3 L=0.28u W=0.80u nf=1
x_del_x21_M6 comp_done_delayed_n x_del_net20 vss vss nfet_03v3 L=0.28u W=0.42u nf=1
x_nand_settle_M2 x_nand_settle_net1 comp_done_delayed_n vss vss nfet_03v3 L=0.28u W=0.50u nf=1
x_nand_settle_M3 gate_settle comp_done_inv vdd vdd pfet_03v3 L=0.28u W=1.0u nf=1
x_nand_settle_M1 gate_settle comp_done_delayed_n vdd vdd pfet_03v3 L=0.28u W=1.0u nf=1
x_nand_settle_M4 gate_settle comp_done_inv x_nand_settle_net1 vss nfet_03v3 L=0.28u W=0.50u nf=1
x_start_del_x1_M5 x_start_del_net1 start vdd vdd pfet_03v3 L=0.28u W=0.80u nf=1
x_start_del_x1_M6 x_start_del_net1 start vss vss nfet_03v3 L=0.28u W=0.42u nf=1
x_start_del_x2_M5 x_start_del_net2 x_start_del_net1 vdd vdd pfet_03v3 L=0.28u W=0.80u nf=1
x_start_del_x2_M6 x_start_del_net2 x_start_del_net1 vss vss nfet_03v3 L=0.28u W=0.42u nf=1
x_start_del_x3_M5 x_start_del_net3 x_start_del_net2 vdd vdd pfet_03v3 L=0.28u W=0.80u nf=1
x_start_del_x3_M6 x_start_del_net3 x_start_del_net2 vss vss nfet_03v3 L=0.28u W=0.42u nf=1
x_start_del_x4_M5 x_start_del_net4 x_start_del_net3 vdd vdd pfet_03v3 L=0.28u W=0.80u nf=1
x_start_del_x4_M6 x_start_del_net4 x_start_del_net3 vss vss nfet_03v3 L=0.28u W=0.42u nf=1
x_start_del_x5_M5 x_start_del_net5 x_start_del_net4 vdd vdd pfet_03v3 L=0.28u W=0.80u nf=1
x_start_del_x5_M6 x_start_del_net5 x_start_del_net4 vss vss nfet_03v3 L=0.28u W=0.42u nf=1
x_start_del_x6_M5 x_start_del_net6 x_start_del_net5 vdd vdd pfet_03v3 L=0.28u W=0.80u nf=1
x_start_del_x6_M6 x_start_del_net6 x_start_del_net5 vss vss nfet_03v3 L=0.28u W=0.42u nf=1
x_start_del_x7_M5 x_start_del_net7 x_start_del_net6 vdd vdd pfet_03v3 L=0.28u W=0.80u nf=1
x_start_del_x7_M6 x_start_del_net7 x_start_del_net6 vss vss nfet_03v3 L=0.28u W=0.42u nf=1
x_start_del_x8_M5 x_start_del_net8 x_start_del_net7 vdd vdd pfet_03v3 L=0.28u W=0.80u nf=1
x_start_del_x8_M6 x_start_del_net8 x_start_del_net7 vss vss nfet_03v3 L=0.28u W=0.42u nf=1
x_start_del_x9_M5 x_start_del_net9 x_start_del_net8 vdd vdd pfet_03v3 L=0.28u W=0.80u nf=1
x_start_del_x9_M6 x_start_del_net9 x_start_del_net8 vss vss nfet_03v3 L=0.28u W=0.42u nf=1
x_start_del_x10_M5 x_start_del_net10 x_start_del_net9 vdd vdd pfet_03v3 L=0.28u W=0.80u nf=1
x_start_del_x10_M6 x_start_del_net10 x_start_del_net9 vss vss nfet_03v3 L=0.28u W=0.42u nf=1
x_start_del_x11_M5 x_start_del_net11 x_start_del_net10 vdd vdd pfet_03v3 L=0.28u W=0.80u nf=1
x_start_del_x11_M6 x_start_del_net11 x_start_del_net10 vss vss nfet_03v3 L=0.28u W=0.42u nf=1
x_start_del_x12_M5 x_start_del_net12 x_start_del_net11 vdd vdd pfet_03v3 L=0.28u W=0.80u nf=1
x_start_del_x12_M6 x_start_del_net12 x_start_del_net11 vss vss nfet_03v3 L=0.28u W=0.42u nf=1
x_start_del_x13_M5 x_start_del_net13 x_start_del_net12 vdd vdd pfet_03v3 L=0.28u W=0.80u nf=1
x_start_del_x13_M6 x_start_del_net13 x_start_del_net12 vss vss nfet_03v3 L=0.28u W=0.42u nf=1
x_start_del_x14_M5 x_start_del_net14 x_start_del_net13 vdd vdd pfet_03v3 L=0.28u W=0.80u nf=1
x_start_del_x14_M6 x_start_del_net14 x_start_del_net13 vss vss nfet_03v3 L=0.28u W=0.42u nf=1
x_start_del_x15_M5 x_start_del_net15 x_start_del_net14 vdd vdd pfet_03v3 L=0.28u W=0.80u nf=1
x_start_del_x15_M6 x_start_del_net15 x_start_del_net14 vss vss nfet_03v3 L=0.28u W=0.42u nf=1
x_start_del_x16_M5 x_start_del_net16 x_start_del_net15 vdd vdd pfet_03v3 L=0.28u W=0.80u nf=1
x_start_del_x16_M6 x_start_del_net16 x_start_del_net15 vss vss nfet_03v3 L=0.28u W=0.42u nf=1
x_start_del_x17_M5 x_start_del_net17 x_start_del_net16 vdd vdd pfet_03v3 L=0.28u W=0.80u nf=1
x_start_del_x17_M6 x_start_del_net17 x_start_del_net16 vss vss nfet_03v3 L=0.28u W=0.42u nf=1
x_start_del_x18_M5 x_start_del_net18 x_start_del_net17 vdd vdd pfet_03v3 L=0.28u W=0.80u nf=1
x_start_del_x18_M6 x_start_del_net18 x_start_del_net17 vss vss nfet_03v3 L=0.28u W=0.42u nf=1
x_start_del_x19_M5 x_start_del_net19 x_start_del_net18 vdd vdd pfet_03v3 L=0.28u W=0.80u nf=1
x_start_del_x19_M6 x_start_del_net19 x_start_del_net18 vss vss nfet_03v3 L=0.28u W=0.42u nf=1
x_start_del_x20_M5 x_start_del_net20 x_start_del_net19 vdd vdd pfet_03v3 L=0.28u W=0.80u nf=1
x_start_del_x20_M6 x_start_del_net20 x_start_del_net19 vss vss nfet_03v3 L=0.28u W=0.42u nf=1
x_start_del_x21_M5 x_start_del_net21 x_start_del_net20 vdd vdd pfet_03v3 L=0.28u W=0.80u nf=1
x_start_del_x21_M6 x_start_del_net21 x_start_del_net20 vss vss nfet_03v3 L=0.28u W=0.42u nf=1
x_start_del_x22_M5 x_start_del_net22 x_start_del_net21 vdd vdd pfet_03v3 L=0.28u W=0.80u nf=1
x_start_del_x22_M6 x_start_del_net22 x_start_del_net21 vss vss nfet_03v3 L=0.28u W=0.42u nf=1
x_start_del_x23_M5 x_start_del_net23 x_start_del_net22 vdd vdd pfet_03v3 L=0.28u W=0.80u nf=1
x_start_del_x23_M6 x_start_del_net23 x_start_del_net22 vss vss nfet_03v3 L=0.28u W=0.42u nf=1
x_start_del_x24_M5 x_start_del_net24 x_start_del_net23 vdd vdd pfet_03v3 L=0.28u W=0.80u nf=1
x_start_del_x24_M6 x_start_del_net24 x_start_del_net23 vss vss nfet_03v3 L=0.28u W=0.42u nf=1
x_start_del_x25_M5 x_start_del_net25 x_start_del_net24 vdd vdd pfet_03v3 L=0.28u W=0.80u nf=1
x_start_del_x25_M6 x_start_del_net25 x_start_del_net24 vss vss nfet_03v3 L=0.28u W=0.42u nf=1
x_start_del_x26_M5 x_start_del_net26 x_start_del_net25 vdd vdd pfet_03v3 L=0.28u W=0.80u nf=1
x_start_del_x26_M6 x_start_del_net26 x_start_del_net25 vss vss nfet_03v3 L=0.28u W=0.42u nf=1
x_start_del_x27_M5 x_start_del_net27 x_start_del_net26 vdd vdd pfet_03v3 L=0.28u W=0.80u nf=1
x_start_del_x27_M6 x_start_del_net27 x_start_del_net26 vss vss nfet_03v3 L=0.28u W=0.42u nf=1
x_start_del_x28_M5 x_start_del_net28 x_start_del_net27 vdd vdd pfet_03v3 L=0.28u W=0.80u nf=1
x_start_del_x28_M6 x_start_del_net28 x_start_del_net27 vss vss nfet_03v3 L=0.28u W=0.42u nf=1
x_start_del_x29_M5 x_start_del_net29 x_start_del_net28 vdd vdd pfet_03v3 L=0.28u W=0.80u nf=1
x_start_del_x29_M6 x_start_del_net29 x_start_del_net28 vss vss nfet_03v3 L=0.28u W=0.42u nf=1
x_start_del_x30_M5 x_start_del_net30 x_start_del_net29 vdd vdd pfet_03v3 L=0.28u W=0.80u nf=1
x_start_del_x30_M6 x_start_del_net30 x_start_del_net29 vss vss nfet_03v3 L=0.28u W=0.42u nf=1
x_start_del_x31_M5 x_start_del_net31 x_start_del_net30 vdd vdd pfet_03v3 L=0.28u W=0.80u nf=1
x_start_del_x31_M6 x_start_del_net31 x_start_del_net30 vss vss nfet_03v3 L=0.28u W=0.42u nf=1
x_start_del_x32_M5 x_start_del_net32 x_start_del_net31 vdd vdd pfet_03v3 L=0.28u W=0.80u nf=1
x_start_del_x32_M6 x_start_del_net32 x_start_del_net31 vss vss nfet_03v3 L=0.28u W=0.42u nf=1
x_start_del_x33_M5 x_start_del_net33 x_start_del_net32 vdd vdd pfet_03v3 L=0.28u W=0.80u nf=1
x_start_del_x33_M6 x_start_del_net33 x_start_del_net32 vss vss nfet_03v3 L=0.28u W=0.42u nf=1
x_start_del_x34_M5 x_start_del_net34 x_start_del_net33 vdd vdd pfet_03v3 L=0.28u W=0.80u nf=1
x_start_del_x34_M6 x_start_del_net34 x_start_del_net33 vss vss nfet_03v3 L=0.28u W=0.42u nf=1
x_start_del_x35_M5 x_start_del_net35 x_start_del_net34 vdd vdd pfet_03v3 L=0.28u W=0.80u nf=1
x_start_del_x35_M6 x_start_del_net35 x_start_del_net34 vss vss nfet_03v3 L=0.28u W=0.42u nf=1
x_start_del_x36_M5 x_start_del_net36 x_start_del_net35 vdd vdd pfet_03v3 L=0.28u W=0.80u nf=1
x_start_del_x36_M6 x_start_del_net36 x_start_del_net35 vss vss nfet_03v3 L=0.28u W=0.42u nf=1
x_start_del_x37_M5 x_start_del_net37 x_start_del_net36 vdd vdd pfet_03v3 L=0.28u W=0.80u nf=1
x_start_del_x37_M6 x_start_del_net37 x_start_del_net36 vss vss nfet_03v3 L=0.28u W=0.42u nf=1
x_start_del_x38_M5 x_start_del_net38 x_start_del_net37 vdd vdd pfet_03v3 L=0.28u W=0.80u nf=1
x_start_del_x38_M6 x_start_del_net38 x_start_del_net37 vss vss nfet_03v3 L=0.28u W=0.42u nf=1
x_start_del_x39_M5 x_start_del_net39 x_start_del_net38 vdd vdd pfet_03v3 L=0.28u W=0.80u nf=1
x_start_del_x39_M6 x_start_del_net39 x_start_del_net38 vss vss nfet_03v3 L=0.28u W=0.42u nf=1
x_start_del_x40_M5 x_start_del_net40 x_start_del_net39 vdd vdd pfet_03v3 L=0.28u W=0.80u nf=1
x_start_del_x40_M6 x_start_del_net40 x_start_del_net39 vss vss nfet_03v3 L=0.28u W=0.42u nf=1
x_start_del_x41_M5 x_start_del_net41 x_start_del_net40 vdd vdd pfet_03v3 L=0.28u W=0.80u nf=1
x_start_del_x41_M6 x_start_del_net41 x_start_del_net40 vss vss nfet_03v3 L=0.28u W=0.42u nf=1
x_start_del_x42_M5 x_start_del_net42 x_start_del_net41 vdd vdd pfet_03v3 L=0.28u W=0.80u nf=1
x_start_del_x42_M6 x_start_del_net42 x_start_del_net41 vss vss nfet_03v3 L=0.28u W=0.42u nf=1
x_start_del_x43_M5 x_start_del_net43 x_start_del_net42 vdd vdd pfet_03v3 L=0.28u W=0.80u nf=1
x_start_del_x43_M6 x_start_del_net43 x_start_del_net42 vss vss nfet_03v3 L=0.28u W=0.42u nf=1
x_start_del_x44_M5 x_start_del_net44 x_start_del_net43 vdd vdd pfet_03v3 L=0.28u W=0.80u nf=1
x_start_del_x44_M6 x_start_del_net44 x_start_del_net43 vss vss nfet_03v3 L=0.28u W=0.42u nf=1
x_start_del_x45_M5 start_n x_start_del_net44 vdd vdd pfet_03v3 L=0.28u W=0.80u nf=1
x_start_del_x45_M6 start_n x_start_del_net44 vss vss nfet_03v3 L=0.28u W=0.42u nf=1
x_inv_dn_M5 done_n done vdd vdd pfet_03v3 L=0.28u W=0.80u nf=1
x_inv_dn_M6 done_n done vss vss nfet_03v3 L=0.28u W=0.42u nf=1
x_nand_ctrl_M2 x_nand_ctrl_net1 done_n vss vss nfet_03v3 L=0.28u W=0.50u nf=1
x_nand_ctrl_M3 gate_ctrl start_n vdd vdd pfet_03v3 L=0.28u W=1.0u nf=1
x_nand_ctrl_M1 gate_ctrl done_n vdd vdd pfet_03v3 L=0.28u W=1.0u nf=1
x_nand_ctrl_M4 gate_ctrl start_n x_nand_ctrl_net1 vss nfet_03v3 L=0.28u W=0.50u nf=1
x_nor_rstl_x1_M5 x_nor_rstl_A_b gate_settle vdd vdd pfet_03v3 L=0.28u W=0.80u nf=1
x_nor_rstl_x1_M6 x_nor_rstl_A_b gate_settle vss vss nfet_03v3 L=0.28u W=0.42u nf=1
x_nor_rstl_x2_M5 x_nor_rstl_B_b gate_ctrl vdd vdd pfet_03v3 L=0.28u W=0.80u nf=1
x_nor_rstl_x2_M6 x_nor_rstl_B_b gate_ctrl vss vss nfet_03v3 L=0.28u W=0.42u nf=1
x_nor_rstl_x3_M2 x_nor_rstl_x3_net1 x_nor_rstl_B_b vss vss nfet_03v3 L=0.28u W=0.50u nf=1
x_nor_rstl_x3_M3 x_nor_rstl_net1 x_nor_rstl_A_b vdd vdd pfet_03v3 L=0.28u W=1.0u nf=1
x_nor_rstl_x3_M1 x_nor_rstl_net1 x_nor_rstl_B_b vdd vdd pfet_03v3 L=0.28u W=1.0u nf=1
x_nor_rstl_x3_M4 x_nor_rstl_net1 x_nor_rstl_A_b x_nor_rstl_x3_net1 vss nfet_03v3 L=0.28u W=0.50u nf=1
x_nor_rstl_x4_M5 rst_latch x_nor_rstl_net1 vdd vdd pfet_03v3 L=0.28u W=0.80u nf=1
x_nor_rstl_x4_M6 rst_latch x_nor_rstl_net1 vss vss nfet_03v3 L=0.28u W=0.42u nf=1
x_nand_done_M2 x_nand_done_net1 comp_done vss vss nfet_03v3 L=0.28u W=0.50u nf=1
x_nand_done_M3 done_nand Q7 vdd vdd pfet_03v3 L=0.28u W=1.0u nf=1
x_nand_done_M1 done_nand comp_done vdd vdd pfet_03v3 L=0.28u W=1.0u nf=1
x_nand_done_M4 done_nand Q7 x_nand_done_net1 vss nfet_03v3 L=0.28u W=0.50u nf=1
x_inv_done_M5 done done_nand vdd vdd pfet_03v3 L=0.28u W=0.80u nf=1
x_inv_done_M6 done done_nand vss vss nfet_03v3 L=0.28u W=0.42u nf=1
.ends async_sar
