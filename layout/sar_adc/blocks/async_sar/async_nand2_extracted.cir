* Extracted by KLayout with GF180MCU LVS runset on : 27/08/2026 09:39

.SUBCKT async_nand2 output input_A input_B VDD VSS
M$1 VDD input_B output VDD pfet_03v3 L=0.28U W=1U AS=0.65P AD=0.65P PS=3.3U
+ PD=3.3U
M$2 VDD input_A output VDD pfet_03v3 L=0.28U W=1U AS=0.65P AD=0.65P PS=3.3U
+ PD=3.3U
M$3 VSS input_B \$4 VSS nfet_03v3 L=0.28U W=0.5U AS=0.305P AD=0.305P PS=2.22U
+ PD=2.22U
M$4 \$4 input_A output VSS nfet_03v3 L=0.28U W=0.5U AS=0.305P AD=0.305P
+ PS=2.22U PD=2.22U
.ENDS async_nand2
