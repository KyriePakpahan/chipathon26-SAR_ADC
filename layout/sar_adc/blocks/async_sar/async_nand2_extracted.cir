* Extracted by KLayout with GF180MCU LVS runset on : 19/08/2026 18:56

.SUBCKT async_nand2
M$1 7 4 6 7 nfet_03v3 L=0.28U W=0.5U AS=0.305P AD=0.305P PS=2.22U PD=2.22U
M$2 6 3 2 7 nfet_03v3 L=0.28U W=0.5U AS=0.305P AD=0.305P PS=2.22U PD=2.22U
M$3 1 3 2 1 pfet_03v3 L=0.28U W=1U AS=0.65P AD=0.65P PS=3.3U PD=3.3U
M$4 1 4 2 1 pfet_03v3 L=0.28U W=1U AS=0.65P AD=0.65P PS=3.3U PD=3.3U
.ENDS async_nand2
