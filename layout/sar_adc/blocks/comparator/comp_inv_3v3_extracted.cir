* Extracted by KLayout with GF180MCU LVS runset on : 11/08/2026 17:15

.SUBCKT comp_inv_3v3 vo vi vdd vss
M$1 vdd vi vo vdd pfet_03v3 L=0.28U W=0.8U AS=0.52P AD=0.52P PS=2.9U PD=2.9U
M$2 vss vi vo vss nfet_03v3 L=0.28U W=0.42U AS=0.2646P AD=0.2646P PS=2.1U
+ PD=2.1U
.ENDS comp_inv_3v3
