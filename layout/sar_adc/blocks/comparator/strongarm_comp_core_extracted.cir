* Extracted by KLayout with GF180MCU LVS runset on : 19/08/2026 18:47

.SUBCKT strongarm_comp_core out_n out_p rst_latch vdd vin_p vin_n vss
M$1 vdd rst_latch \$10 vdd pfet_03v3 L=0.28U W=2U AS=1.3P AD=1.3P PS=5.3U
+ PD=5.3U
M$2 vdd rst_latch out_p vdd pfet_03v3 L=0.28U W=2U AS=1.3P AD=1.3P PS=5.3U
+ PD=5.3U
M$3 vdd rst_latch \$11 vdd pfet_03v3 L=0.28U W=2U AS=1.3P AD=1.3P PS=5.3U
+ PD=5.3U
M$4 vdd rst_latch out_n vdd pfet_03v3 L=0.28U W=2U AS=1.3P AD=1.3P PS=5.3U
+ PD=5.3U
M$5 \$9 vin_p \$10 vss nfet_03v3 L=0.28U W=6U AS=3.66P AD=3.66P PS=13.22U
+ PD=13.22U
M$6 vdd out_p out_n vdd pfet_03v3 L=0.28U W=4.2U AS=2.73P AD=2.73P PS=9.7U
+ PD=9.7U
M$7 vdd out_n out_p vdd pfet_03v3 L=0.28U W=4.2U AS=2.73P AD=2.73P PS=9.7U
+ PD=9.7U
M$8 \$9 vin_n \$11 vss nfet_03v3 L=0.28U W=6U AS=3.66P AD=3.66P PS=13.22U
+ PD=13.22U
M$9 vss rst_latch \$9 vss nfet_03v3 L=0.28U W=8U AS=4.88P AD=4.88P PS=17.22U
+ PD=17.22U
M$10 \$10 out_n out_p vss nfet_03v3 L=0.28U W=3.5U AS=2.135P AD=2.135P PS=8.22U
+ PD=8.22U
M$11 \$11 out_p out_n vss nfet_03v3 L=0.28U W=3.5U AS=2.135P AD=2.135P PS=8.22U
+ PD=8.22U
.ENDS strongarm_comp_core
