** sch_path: /foss/designs/chipathon26-SAR_ADC/xschem/sar_adc/blocks/sample_hold/sample_hold.sch
.subckt sample_hold vin sample_en vhold vdd vss
*.PININFO vin:I sample_en:I vhold:O vdd:B vss:B
x_inv vdd clkb sample_en vss inv_sh
M1 vhold sample_en vin vss nfet_03v3 L=0.28u W=4.00u nf=2
M2 vin clkb vhold vdd pfet_03v3 L=0.28u W=8.00u nf=2
XC2 vhold vss cap_mim_2f0fF c_width=15e-6 c_length=10e-6
.ends

* expanding   symbol:  sar_adc/blocks/sample_hold/inv_sh.sym # of pins=4
** sym_path: /foss/designs/chipathon26-SAR_ADC/xschem/sar_adc/blocks/sample_hold/inv_sh.sym
** sch_path: /foss/designs/chipathon26-SAR_ADC/xschem/sar_adc/blocks/sample_hold/inv_sh.sch
.subckt inv_sh vdd vo vi vss
*.PININFO vdd:B vi:I vo:O vss:B
M1 vo vi vss vss nfet_03v3 L=0.28u W=1u nf=1
M2 vo vi vdd vdd pfet_03v3 L=0.28u W=2u nf=1
.ends
