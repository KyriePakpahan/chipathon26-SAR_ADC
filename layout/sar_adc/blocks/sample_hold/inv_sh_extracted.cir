* Extracted by KLayout with GF180MCU LVS runset on : 11/08/2026 18:40

.SUBCKT inv_sh vdd vo vi vss
M$1 vss vi vo vss nfet_03v3 L=0.28U W=1U AS=0.61P AD=0.61P PS=3.22U PD=3.22U
M$2 vdd vi vo vdd pfet_03v3 L=0.28U W=2U AS=1.3P AD=1.3P PS=5.3U PD=5.3U
.ENDS inv_sh
