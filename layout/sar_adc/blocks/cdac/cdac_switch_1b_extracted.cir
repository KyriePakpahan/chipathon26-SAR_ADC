* Extracted by KLayout with GF180MCU LVS runset on : 19/08/2026 22:16

.SUBCKT cdac_switch_1b bit_b vdd bot bit vref vss
M$1 bot bit_b vref vdd pfet_03v3 L=0.28U W=32U AS=9.88P AD=9.88P PS=40.94U
+ PD=40.94U
M$9 bot bit_b vss vss nfet_03v3 L=0.28U W=24U AS=7.64P AD=7.64P PS=31.82U
+ PD=31.82U
M$15 bit_b bit vss vss nfet_03v3 L=0.28U W=8U AS=3.48P AD=3.48P PS=13.74U
+ PD=13.74U
M$17 bit_b bit vdd vdd pfet_03v3 L=0.28U W=16U AS=5.72P AD=5.72P PS=22.86U
+ PD=22.86U
.ENDS cdac_switch_1b
