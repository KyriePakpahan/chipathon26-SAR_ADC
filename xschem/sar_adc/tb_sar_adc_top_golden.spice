* Golden Schematic Testbench for SAR ADC Top (tb_sar_adc_top_golden.spice)

.param fnoicor=0
.param sw_stat_mismatch=0
.lib /foss/pdks/gf180mcuD/libs.tech/ngspice/sm141064.ngspice typical
.lib /foss/pdks/gf180mcuD/libs.tech/ngspice/sm141064.ngspice mimcap_typical
.lib /foss/pdks/gf180mcuD/libs.tech/ngspice/sm141064.ngspice cap_mim

.include ../../xschem/sar_adc/tb_sar_adc_top.spice

.options method=gear reltol=1e-3 vntol=1e-4 abstol=1e-12
.control
set filetype=ascii
tran 0.1n 60n
echo "=== SCHEMATIC GOLDEN RESULTS ==="
let v_d7 = v(x1.dout[7])[length(v(x1.dout[7]))-1]
let v_d6 = v(x1.dout[6])[length(v(x1.dout[6]))-1]
let v_d5 = v(x1.dout[5])[length(v(x1.dout[5]))-1]
let v_d4 = v(x1.dout[4])[length(v(x1.dout[4]))-1]
let v_d3 = v(x1.dout[3])[length(v(x1.dout[3]))-1]
let v_d2 = v(x1.dout[2])[length(v(x1.dout[2]))-1]
let v_d1 = v(x1.dout[1])[length(v(x1.dout[1]))-1]
let v_d0 = v(x1.dout[0])[length(v(x1.dout[0]))-1]
let v_done = v(x1.done)[length(v(x1.done))-1]
print v_d7 v_d6 v_d5 v_d4 v_d3 v_d2 v_d1 v_d0 v_done
quit
.endc
.end
