** Complete Monolithic 8-bit Asynchronous SAR ADC Top Netlist (sar_adc_top.spice)

* 1. Sample & Hold Subcircuit
.subckt inv_sh vdd vo vi vss
XM1 vo vi vss vss nfet_03v3 L=0.28u W=1u nf=1
XM2 vo vi vdd vdd pfet_03v3 L=0.28u W=2u nf=1
.ends

.subckt sample_hold vin sample_en vhold vdd vss
x_inv vdd clkb sample_en vss inv_sh
XM1 vhold sample_en vin vss nfet_03v3 L=0.28u W=4.00u nf=2
XM2 vin clkb vhold vdd pfet_03v3 L=0.28u W=8.00u nf=2
XC2 vhold vss cap_mim_2f0fF c_width=15e-6 c_length=10e-6
.ends

* 2. CDAC 8-Bit Subcircuit
.subckt cdac_switch_1b bit_in vref vdd vss bot
XM_inv_p bit_b bit_in vdd vdd pfet_03v3 L=0.28u W=2.0u nf=1
XM_inv_n bit_b bit_in vss vss nfet_03v3 L=0.28u W=1.0u nf=1
XM_vref bot bit_b vref vdd pfet_03v3 L=0.28u W=6.0u nf=2
XM_gnd  bot bit_in vss vss nfet_03v3 L=0.28u W=3.0u nf=2
.ends

.subckt cdac_8bit vref dac_in[7] dac_in[6] dac_in[5] dac_in[4] dac_in[3] dac_in[2] dac_in[1] dac_in[0] vdac vdd vss
XSW0 dac_in[0] vref vdd vss bot0 cdac_switch_1b
XC0 vdac bot0 cap_mim_2f0fF c_width=5e-6 c_length=5e-6
XSW1 dac_in[1] vref vdd vss bot1 cdac_switch_1b
XC1 vdac bot1 cap_mim_2f0fF c_width=5e-6 c_length=5e-6 m=2
XSW2 dac_in[2] vref vdd vss bot2 cdac_switch_1b
XC2 vdac bot2 cap_mim_2f0fF c_width=5e-6 c_length=5e-6 m=4
XSW3 dac_in[3] vref vdd vss bot3 cdac_switch_1b
XC3 vdac bot3 cap_mim_2f0fF c_width=5e-6 c_length=5e-6 m=8
XSW4 dac_in[4] vref vdd vss bot4 cdac_switch_1b
XC4 vdac bot4 cap_mim_2f0fF c_width=5e-6 c_length=5e-6 m=16
XSW5 dac_in[5] vref vdd vss bot5 cdac_switch_1b
XC5 vdac bot5 cap_mim_2f0fF c_width=5e-6 c_length=5e-6 m=32
XSW6 dac_in[6] vref vdd vss bot6 cdac_switch_1b
XC6 vdac bot6 cap_mim_2f0fF c_width=5e-6 c_length=5e-6 m=64
XSW7 dac_in[7] vref vdd vss bot7 cdac_switch_1b
XC7 vdac bot7 cap_mim_2f0fF c_width=5e-6 c_length=5e-6 m=128
.ends

* 3. StrongArm Dynamic Comparator Subcircuit
.subckt comp_inv_3v3 vi vo vdd vss
XM1 vo vi vdd vdd pfet_03v3 L=0.28u W=1.0u nf=1
XM2 vo vi vss vss nfet_03v3 L=0.28u W=0.5u nf=1
.ends

.subckt comp_nand_3v3 a b out vdd vss
XM1 out a vdd vdd pfet_03v3 L=0.28u W=1.0u nf=1
XM2 out b vdd vdd pfet_03v3 L=0.28u W=1.0u nf=1
XM3 out a mid vss nfet_03v3 L=0.28u W=1.0u nf=1
XM4 mid b vss vss nfet_03v3 L=0.28u W=1.0u nf=1
.ends

.subckt comp_xor_fast a b out vdd vss
x1 a b nab vdd vss comp_nand_3v3
x2 a nab a_nab vdd vss comp_nand_3v3
x3 b nab b_nab vdd vss comp_nand_3v3
x4 a_nab b_nab out vdd vss comp_nand_3v3
.ends

.subckt strongarm_comp_core vin_p vin_n rst_latch vdd vss out_p out_n
XM_tail tail rst_latch vss vss nfet_03v3 L=0.28u W=4.0u nf=2
XM_in_p dn vin_p tail vss nfet_03v3 L=0.28u W=4.0u nf=2
XM_in_n dp vin_n tail vss nfet_03v3 L=0.28u W=4.0u nf=2
XM_cross_n out_n out_p dn vss nfet_03v3 L=0.28u W=2.0u nf=1
XM_cross_p out_p out_n dp vss nfet_03v3 L=0.28u W=2.0u nf=1
XM_latch_n out_n out_p vdd vdd pfet_03v3 L=0.28u W=2.0u nf=1
XM_latch_p out_p out_n vdd vdd pfet_03v3 L=0.28u W=2.0u nf=1
XM_rst_n out_n rst_latch vdd vdd pfet_03v3 L=0.28u W=1.0u nf=1
XM_rst_p out_p rst_latch vdd vdd pfet_03v3 L=0.28u W=1.0u nf=1
XM_rst_dn dn rst_latch vdd vdd pfet_03v3 L=0.28u W=1.0u nf=1
XM_rst_dp dp rst_latch vdd vdd pfet_03v3 L=0.28u W=1.0u nf=1
.ends

.subckt strongarm_comp vin_p vin_n rst_latch vdd vss out_p out_n comp_done
x_core vin_p vin_n rst_latch vdd vss raw_p raw_n strongarm_comp_core
x_inv_p raw_p out_p vdd vss comp_inv_3v3
x_inv_n raw_n out_n vdd vss comp_inv_3v3
x_done_xor out_p out_n comp_done vdd vss comp_xor_fast
.ends

* 4. Asynchronous SAR Logic Subcircuit
.subckt async_inverter vdd input out vss
XM5 out input vdd vdd pfet_03v3 L=0.28u W=0.80u nf=1
XM6 out input vss vss nfet_03v3 L=0.28u W=0.42u nf=1
.ends

.subckt async_nor2 a b out vdd vss
XM1 mid a vdd vdd pfet_03v3 L=0.28u W=0.80u nf=1
XM2 out b mid vdd pfet_03v3 L=0.28u W=0.80u nf=1
XM3 out a vss vss nfet_03v3 L=0.28u W=0.42u nf=1
XM4 out b vss vss nfet_03v3 L=0.28u W=0.42u nf=1
.ends

.subckt async_nand2 a b out vdd vss
XM1 out a vdd vdd pfet_03v3 L=0.28u W=0.80u nf=1
XM2 out b vdd vdd pfet_03v3 L=0.28u W=0.80u nf=1
XM3 out a mid vss nfet_03v3 L=0.28u W=0.42u nf=1
XM4 mid b vss vss nfet_03v3 L=0.28u W=0.42u nf=1
.ends

.subckt dff_cell vdd vss clk d q q_bar rst_n
XM1 clk_n clk vdd vdd pfet_03v3 L=0.28u W=1.0u nf=1
XM2 clk_n clk vss vss nfet_03v3 L=0.28u W=0.50u nf=1
XM3 M clk_n D_int vdd pfet_03v3 L=0.28u W=1.0u nf=1
XM4 D_int clk M vss nfet_03v3 L=0.28u W=0.50u nf=1
XM5 M_bar M vdd vdd pfet_03v3 L=0.28u W=1.0u nf=1
XM6 M_bar M vss vss nfet_03v3 L=0.28u W=0.50u nf=1
XM7 M M_bar vdd vdd pfet_03v3 L=2.0u W=0.42u nf=1
XM8 M M_bar vss vss nfet_03v3 L=2.4u W=0.42u nf=1
XM9 S clk M_bar vdd pfet_03v3 L=0.28u W=1.0u nf=1
XM10 M_bar clk_n S vss nfet_03v3 L=0.28u W=0.50u nf=1
XM11 Q_bar S vdd vdd pfet_03v3 L=0.28u W=1.0u nf=1
XM12 Q_bar rst_n vdd vdd pfet_03v3 L=0.28u W=1.0u nf=1
XM13 Q_bar S net1 vss nfet_03v3 L=0.28u W=0.50u nf=1
XM14 net1 rst_n vss vss nfet_03v3 L=0.28u W=0.50u nf=1
XM15 Q Q_bar vdd vdd pfet_03v3 L=0.28u W=1.0u nf=1
XM16 Q Q_bar vss vss nfet_03v3 L=0.28u W=0.50u nf=1
XM17 S Q_bar vdd vdd pfet_03v3 L=2.0u W=0.42u nf=1
XM18 S Q_bar vss vss nfet_03v3 L=2.4u W=0.42u nf=1
XM19 D_int d vdd vdd pfet_03v3 L=0.28u W=1.0u nf=1
XM20 D_int d vss vss nfet_03v3 L=0.28u W=0.50u nf=1
.ends

.subckt shift_reg_8bit vdd vss Q0 Q1 Q2 Q3 Q4 Q5 Q6 Q7 done serial_in clk rst_n
x1 vdd vss clk serial_in Q0 net1 rst_n dff_cell
x2 vdd vss clk Q0 Q1 net2 rst_n dff_cell
x3 vdd vss clk Q1 Q2 net3 rst_n dff_cell
x4 vdd vss clk Q2 Q3 net4 rst_n dff_cell
x5 vdd vss clk Q3 Q4 net5 rst_n dff_cell
x6 vdd vss clk Q4 Q5 net6 rst_n dff_cell
x7 vdd vss clk Q5 Q6 net7 rst_n dff_cell
x8 vdd vss clk Q6 Q7 net8 rst_n dff_cell
x9 vdd vss clk Q7 done net9 rst_n dff_cell
.ends

.subckt bit_reg vdd vss clk_sample clk_latch comp_out dout rst_n
x1 vdd clk_sample net1 vss async_inverter
x2 vdd clk_latch net2 vss async_inverter
x3 net1 net2 clk_gated vdd vss async_nand2
x4 vdd vss clk_gated comp_out dout q_bar rst_n dff_cell
.ends

.subckt async_start_delay vdd vss in out
x1 vdd in net1 vss async_inverter
x2 vdd net1 net2 vss async_inverter
x3 vdd net2 net3 vss async_inverter
x4 vdd net3 net4 vss async_inverter
x5 vdd net4 net5 vss async_inverter
x6 vdd net5 net6 vss async_inverter
x7 vdd net6 net7 vss async_inverter
x8 vdd net7 net8 vss async_inverter
x9 vdd net8 net9 vss async_inverter
x10 vdd net9 net10 vss async_inverter
x11 vdd net10 net11 vss async_inverter
x12 vdd net11 net12 vss async_inverter
x13 vdd net12 net13 vss async_inverter
x14 vdd net13 net14 vss async_inverter
x15 vdd net14 net15 vss async_inverter
x16 vdd net15 net16 vss async_inverter
x17 vdd net16 net17 vss async_inverter
x18 vdd net17 net18 vss async_inverter
x19 vdd net18 net19 vss async_inverter
x20 vdd net19 net20 vss async_inverter
x21 vdd net20 net21 vss async_inverter
x22 vdd net21 net22 vss async_inverter
x23 vdd net22 net23 vss async_inverter
x24 vdd net23 net24 vss async_inverter
x25 vdd net24 net25 vss async_inverter
x26 vdd net25 net26 vss async_inverter
x27 vdd net26 net27 vss async_inverter
x28 vdd net27 net28 vss async_inverter
x29 vdd net28 net29 vss async_inverter
x30 vdd net29 net30 vss async_inverter
x31 vdd net30 net31 vss async_inverter
x32 vdd net31 net32 vss async_inverter
x33 vdd net32 net33 vss async_inverter
x34 vdd net33 net34 vss async_inverter
x35 vdd net34 net35 vss async_inverter
x36 vdd net35 net36 vss async_inverter
x37 vdd net36 net37 vss async_inverter
x38 vdd net37 net38 vss async_inverter
x39 vdd net38 net39 vss async_inverter
x40 vdd net39 net40 vss async_inverter
x41 vdd net40 net41 vss async_inverter
x42 vdd net41 net42 vss async_inverter
x43 vdd net42 net43 vss async_inverter
x44 vdd net43 net44 vss async_inverter
x45 vdd net44 out vss async_inverter
.ends

.subckt async_pulse_settle vdd vss in out
x1 vdd in net1 vss async_inverter
x2 vdd net1 net2 vss async_inverter
x3 vdd net2 net3 vss async_inverter
x4 vdd net3 net4 vss async_inverter
x5 vdd net4 net5 vss async_inverter
x6 vdd net5 net6 vss async_inverter
x7 vdd net6 net7 vss async_inverter
x8 vdd net7 in_delayed_n vss async_inverter
x_nor_pulse in in_delayed_n out vdd vss async_nor2
.ends

.subckt async_sar sample_en rst_latch done dout[7] dout[6] dout[5] dout[4] dout[3] dout[2] dout[1] dout[0] dac_in[7] dac_in[6] dac_in[5] dac_in[4] dac_in[3] dac_in[2] dac_in[1] dac_in[0] start comp_out_p comp_out_n vdd comp_done vss
x_inv_se vdd start sample_en vss async_inverter
x_inv_cd vdd comp_done comp_done_b vss async_inverter
x_sr8 vdd vss Q0 Q1 Q2 Q3 Q4 Q5 Q6 Q7 sr_done vdd comp_done_b sample_en shift_reg_8bit

x_bit_reg_0 vdd vss Q0 comp_done comp_out_p dout[7] sample_en bit_reg
x_bit_reg_1 vdd vss Q1 comp_done comp_out_p dout[6] sample_en bit_reg
x_bit_reg_2 vdd vss Q2 comp_done comp_out_p dout[5] sample_en bit_reg
x_bit_reg_3 vdd vss Q3 comp_done comp_out_p dout[4] sample_en bit_reg
x_bit_reg_4 vdd vss Q4 comp_done comp_out_p dout[3] sample_en bit_reg
x_bit_reg_5 vdd vss Q5 comp_done comp_out_p dout[2] sample_en bit_reg
x_bit_reg_6 vdd vss Q6 comp_done comp_out_p dout[1] sample_en bit_reg
x_bit_reg_7 vdd vss Q7 comp_done comp_out_p dout[0] sample_en bit_reg

x_inv_d0 vdd dout[0] dout_n[0] vss async_inverter
x_inv_d1 vdd dout[1] dout_n[1] vss async_inverter
x_inv_d2 vdd dout[2] dout_n[2] vss async_inverter
x_inv_d3 vdd dout[3] dout_n[3] vss async_inverter
x_inv_d4 vdd dout[4] dout_n[4] vss async_inverter
x_inv_d5 vdd dout[5] dout_n[5] vss async_inverter
x_inv_d6 vdd dout[6] dout_n[6] vss async_inverter
x_inv_d7 vdd dout[7] dout_n[7] vss async_inverter

x_inv_q0 vdd Q0 q_n[0] vss async_inverter
x_inv_q1 vdd Q1 q_n[1] vss async_inverter
x_inv_q2 vdd Q2 q_n[2] vss async_inverter
x_inv_q3 vdd Q3 q_n[3] vss async_inverter
x_inv_q4 vdd Q4 q_n[4] vss async_inverter
x_inv_q5 vdd Q5 q_n[5] vss async_inverter
x_inv_q6 vdd Q6 q_n[6] vss async_inverter

x_nand_dac_7 dout_n[7] sample_en dac_in[7] vdd vss async_nand2
x_nand_dac_6 dout_n[6] q_n[0] dac_in[6] vdd vss async_nand2
x_nand_dac_5 dout_n[5] q_n[1] dac_in[5] vdd vss async_nand2
x_nand_dac_4 dout_n[4] q_n[2] dac_in[4] vdd vss async_nand2
x_nand_dac_3 dout_n[3] q_n[3] dac_in[3] vdd vss async_nand2
x_nand_dac_2 dout_n[2] q_n[4] dac_in[2] vdd vss async_nand2
x_nand_dac_1 dout_n[1] q_n[5] dac_in[1] vdd vss async_nand2
x_nand_dac_0 dout_n[0] q_n[6] dac_in[0] vdd vss async_nand2

x_psettle vdd vss comp_done gate_settle async_pulse_settle
x_start_del vdd vss start start_n async_start_delay
x_inv_dn vdd done done_n vss async_inverter
x_nand_ctrl start_n done_n gate_ctrl vdd vss async_nand2
x_nor_rstl gate_settle gate_ctrl rst_latch vdd vss async_nor2
x_nand_done Q7 comp_done done_nand vdd vss async_nand2
x_inv_done vdd done_nand done vss async_inverter
.ends

* 5. Top Circuit: sar_adc_top
.subckt sar_adc_top vin vref start vdd vss done d7 d6 d5 d4 d3 d2 d1 d0
x_sh vin sample_en vhold vdd vss sample_hold
x_cdac vref dac_in[7] dac_in[6] dac_in[5] dac_in[4] dac_in[3] dac_in[2] dac_in[1] dac_in[0] vdac vdd vss cdac_8bit
x_comp vhold vdac rst_latch vdd vss comp_out_p comp_out_n comp_done strongarm_comp
x_sar sample_en rst_latch done d7 d6 d5 d4 d3 d2 d1 d0 dac_in[7] dac_in[6] dac_in[5] dac_in[4] dac_in[3] dac_in[2] dac_in[1] dac_in[0] start comp_out_p comp_out_n vdd comp_done vss async_sar
.ends
