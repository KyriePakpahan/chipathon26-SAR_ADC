** sch_path: /foss/designs/chipathon26-SAR_ADC/xschem/sar_adc/blocks/cdac/cdac_8bit.sch
**.subckt cdac_8bit vref dac_in[7] dac_in[6] dac_in[5] dac_in[4] dac_in[3] dac_in[2] dac_in[1] dac_in[0] vdac vdd vss
*.ipin vref
*.ipin dac_in[7]
*.ipin dac_in[6]
*.ipin dac_in[5]
*.ipin dac_in[4]
*.ipin dac_in[3]
*.ipin dac_in[2]
*.ipin dac_in[1]
*.ipin dac_in[0]
*.opin vdac
*.iopin vdd
*.iopin vss
XSW0 dac_in[0] vref vdd vss bot0 cdac_switch_1b
XC0 vdac bot0 cap_mim_2f0fF c_width=5e-6 c_length=5e-6
XSW1 dac_in[1] vref vdd vss bot1 cdac_switch_1b
XC1 vdac bot1 cap_mim_2f0fF c_width=5e-6 c_length=5e-6 m=2
XSW2 dac_in[2] vref vdd vss bot2 cdac_switch_1b
XC2 vdac bot2 cap_mim_2f0fF c_width=5e-6 c_length=5e-6 m=4
XSW3 dac_in[3] vref vdd vss bot3 cdac_switch_1b
XC3 vdac bot3 cap_mim_2f0fF c_width=5e-6 c_length=5e-6 m=8
XSW4 dac_in[4] vref vdd vss bot4 cdac_switch_1b
XC4 vdac bot4 cap_mim_2f0fF c_width=5e-6 c_length=5e-6 m=16
XSW5 dac_in[5] vref vdd vss bot5 cdac_switch_1b
XC5 vdac bot5 cap_mim_2f0fF c_width=5e-6 c_length=5e-6 m=32
XSW6 dac_in[6] vref vdd vss bot6 cdac_switch_1b
XC6 vdac bot6 cap_mim_2f0fF c_width=5e-6 c_length=5e-6 m=64
XSW7 dac_in[7] vref vdd vss bot7 cdac_switch_1b
XC7 vdac bot7 cap_mim_2f0fF c_width=5e-6 c_length=5e-6 m=128
XC8 vdac vss cap_mim_2f0fF c_width=5e-6 c_length=5e-6
**.ends

* expanding   symbol:  sar_adc/blocks/cdac/cdac_switch_1b.sym # of pins=5
** sym_path: /foss/designs/chipathon26-SAR_ADC/xschem/sar_adc/blocks/cdac/cdac_switch_1b.sym
** sch_path: /foss/designs/chipathon26-SAR_ADC/xschem/sar_adc/blocks/cdac/cdac_switch_1b.sch
.subckt cdac_switch_1b bit vref vdd vss bot
*.ipin bit
*.iopin vref
*.iopin vdd
*.iopin vss
*.iopin bot
XM1 bit_b bit vdd vdd pfet_03v3 L=0.28u W=8.0u nf=2 ad='int((nf+1)/2) * W/nf * 0.18u' as='int((nf+2)/2) * W/nf * 0.18u' pd='2*int((nf+1)/2) * (W/nf + 0.18u)'
+ ps='2*int((nf+2)/2) * (W/nf + 0.18u)' nrd='0.18u / W' nrs='0.18u / W' sa=0 sb=0 sd=0
XM2 bit_b bit vss vss nfet_03v3 L=0.28u W=4.0u nf=2 ad='int((nf+1)/2) * W/nf * 0.18u' as='int((nf+2)/2) * W/nf * 0.18u' pd='2*int((nf+1)/2) * (W/nf + 0.18u)'
+ ps='2*int((nf+2)/2) * (W/nf + 0.18u)' nrd='0.18u / W' nrs='0.18u / W' sa=0 sb=0 sd=0
XM3 bot bit_b vref vdd pfet_03v3 L=0.28u W=16.0u nf=4 ad='int((nf+1)/2) * W/nf * 0.18u' as='int((nf+2)/2) * W/nf * 0.18u' pd='2*int((nf+1)/2) * (W/nf + 0.18u)'
+ ps='2*int((nf+2)/2) * (W/nf + 0.18u)' nrd='0.18u / W' nrs='0.18u / W' sa=0 sb=0 sd=0
XM6 bot bit_b vss vss nfet_03v3 L=0.28u W=12.0u nf=4 ad='int((nf+1)/2) * W/nf * 0.18u' as='int((nf+2)/2) * W/nf * 0.18u' pd='2*int((nf+1)/2) * (W/nf + 0.18u)'
+ ps='2*int((nf+2)/2) * (W/nf + 0.18u)' nrd='0.18u / W' nrs='0.18u / W' sa=0 sb=0 sd=0
.ends

.end
