* Extracted by KLayout with GF180MCU LVS runset on : 11/08/2026 16:14

.SUBCKT delay_line
M$1 4 3 7 7 pfet_03v3 L=2U W=0.5U AS=0.325P AD=0.325P PS=2.3U PD=2.3U
M$2 5 1 7 7 pfet_03v3 L=2U W=0.5U AS=0.325P AD=0.325P PS=2.3U PD=2.3U
M$3 1 4 7 7 pfet_03v3 L=0.28U W=2U AS=1.3P AD=1.3P PS=5.3U PD=5.3U
M$4 2 5 7 7 pfet_03v3 L=0.28U W=2U AS=1.3P AD=1.3P PS=5.3U PD=5.3U
M$5 2 5 8 9 nfet_03v3 L=2U W=0.42U AS=0.2646P AD=0.2646P PS=2.1U PD=2.1U
M$6 1 4 8 10 nfet_03v3 L=2U W=0.42U AS=0.2646P AD=0.2646P PS=2.1U PD=2.1U
M$7 4 3 8 11 nfet_03v3 L=0.28U W=1.5U AS=0.915P AD=0.915P PS=4.22U PD=4.22U
M$8 5 1 8 12 nfet_03v3 L=0.28U W=1.5U AS=0.915P AD=0.915P PS=4.22U PD=4.22U
.ENDS delay_line
