* NGSPICE file created from sar_adc_top.ext - technology: gf180mcuD

.subckt async_sar start comp_out_p comp_done sample_en rst_latch done dout[0] dac_in[0]
+ dout[1] dac_in[1] dout[2] dac_in[2] dout[3] dac_in[3] dout[4] dac_in[4] dout[5]
+ dac_in[5] dout[6] dac_in[6] dout[7] dac_in[7] a_30228_54264# a_20908_46000# a_37028_54264#
+ a_47028_19064# a_33308_24800# a_23428_54264# a_50628_54264# a_33308_19200# a_16628_54264#
+ a_43828_54264# a_9828_54264# a_35308_29600# a_3028_54264#
X0 start a_2908_50400# a_3028_54264# start pfet_03v3 ad=1.38p pd=4.76u as=0.65p ps=3.3u w=1u l=0.28u
X1 start a_50908_41600# dout[7] start pfet_03v3 ad=1.104p pd=4.36u as=0.52p ps=2.9u w=0.8u l=0.28u
X2 start a_42908_12400# a_44108_12400# start pfet_03v3 ad=1.38p pd=4.76u as=0.65p ps=3.3u w=1u l=0.28u
X3 start comp_done a_33308_19200# start pfet_03v3 ad=1.38p pd=4.76u as=0.65p ps=3.3u w=1u l=0.28u
X4 start a_9308_10960# a_11708_10960# start nfet_03v3 ad=0.66p pd=3.64u as=0.305p ps=2.22u w=0.5u l=0.28u
X5 start a_6508_46000# a_7708_46000# start nfet_03v3 ad=0.66p pd=3.64u as=0.305p ps=2.22u w=0.5u l=0.28u
X6 start a_16228_10824# a_16108_10960# start nfet_03v3 ad=0.66p pd=3.64u as=0.305p ps=2.22u w=0.5u l=0.28u
X7 a_12694_28400# a_10108_29600# a_12508_29600# start nfet_03v3 ad=0.305p pd=2.22u as=0.305p ps=2.22u w=0.5u l=0.28u
X8 start a_44108_1200# a_45308_1200# start nfet_03v3 ad=0.66p pd=3.64u as=0.305p ps=2.22u w=0.5u l=0.28u
X9 start dout[5] a_42508_33600# start nfet_03v3 ad=0.577p pd=3.52u as=0.2646p ps=2.1u w=0.42u l=0.28u
X10 start a_48908_1200# a_50108_1200# start pfet_03v3 ad=1.38p pd=4.76u as=0.65p ps=3.3u w=1u l=0.28u
X11 start a_37028_9464# a_35828_9464# start nfet_03v3 ad=0.66p pd=3.64u as=0.305p ps=2.22u w=0.5u l=0.28u
X12 start a_20908_46000# a_39708_24800# start pfet_03v3 ad=1.104p pd=4.36u as=0.52p ps=2.9u w=0.8u l=0.28u
X13 start a_9308_20560# a_11708_20560# start pfet_03v3 ad=1.38p pd=4.76u as=0.65p ps=3.3u w=1u l=0.28u
X14 start a_53708_6800# a_54908_6800# start pfet_03v3 ad=1.38p pd=4.76u as=0.65p ps=3.3u w=1u l=0.28u
X15 start a_46508_12400# a_47708_12400# start nfet_03v3 ad=0.66p pd=3.64u as=0.305p ps=2.22u w=0.5u l=0.28u
X16 start comp_out_p a_24508_50400# start pfet_03v3 ad=1.104p pd=4.36u as=0.52p ps=2.9u w=0.8u l=0.28u
X17 start a_48508_37600# a_50908_37600# start pfet_03v3 ad=1.38p pd=4.76u as=0.65p ps=3.3u w=1u l=0.28u
X18 start a_25828_1224# a_24508_1360# start pfet_03v3 ad=1.38p pd=4.76u as=0.65p ps=3.3u w=1u l=0.28u
X19 start a_10908_50400# a_9828_54264# start pfet_03v3 ad=1.38p pd=4.76u as=0.65p ps=3.3u w=1u l=0.28u
X20 start a_10628_15624# a_9494_14400# start nfet_03v3 ad=0.66p pd=3.64u as=0.305p ps=2.22u w=0.5u l=0.28u
X21 a_5708_10960# a_2228_10824# a_8108_10960# start pfet_03v3 ad=0.65p pd=3.3u as=0.65p ps=3.3u w=1u l=0.28u
X22 start a_44908_54400# a_46294_53200# start nfet_03v3 ad=0.66p pd=3.64u as=0.305p ps=2.22u w=0.5u l=0.28u
X23 start a_20908_1360# a_19708_1360# start nfet_03v3 ad=0.577p pd=3.52u as=0.2646p ps=2.1u w=0.42u l=2.4u
X24 start a_52628_15064# a_51428_15064# start nfet_03v3 ad=0.66p pd=3.64u as=0.305p ps=2.22u w=0.5u l=0.28u
X25 start a_34508_1200# a_35708_1200# start nfet_03v3 ad=0.66p pd=3.64u as=0.305p ps=2.22u w=0.5u l=0.28u
X26 start a_10108_41600# a_12508_41600# start pfet_03v3 ad=1.38p pd=4.76u as=0.65p ps=3.3u w=1u l=0.28u
X27 start sample_en a_46628_3864# start nfet_03v3 ad=0.66p pd=3.64u as=0.305p ps=2.22u w=0.5u l=0.28u
X28 start a_46628_3864# a_45428_3864# start pfet_03v3 ad=1.38p pd=4.76u as=0.65p ps=3.3u w=1u l=0.28u
X29 a_9494_14400# a_8108_15760# a_9308_15760# start nfet_03v3 ad=0.305p pd=2.22u as=0.305p ps=2.22u w=0.5u l=0.28u
X30 start a_9828_54264# a_9708_54400# start nfet_03v3 ad=0.577p pd=3.52u as=0.2646p ps=2.1u w=0.42u l=0.28u
X31 start a_50108_6800# a_51308_6800# start nfet_03v3 ad=0.66p pd=3.64u as=0.305p ps=2.22u w=0.5u l=0.28u
X32 start a_18508_37600# a_19894_36400# start nfet_03v3 ad=0.66p pd=3.64u as=0.305p ps=2.22u w=0.5u l=0.28u
X33 start a_2228_6024# a_2108_6160# start nfet_03v3 ad=0.66p pd=3.64u as=0.305p ps=2.22u w=0.5u l=0.28u
X34 a_51094_40400# a_48508_41600# a_50908_41600# start nfet_03v3 ad=0.305p pd=2.22u as=0.305p ps=2.22u w=0.5u l=0.28u
X35 start a_22108_6160# a_24508_6160# start pfet_03v3 ad=1.38p pd=4.76u as=0.65p ps=3.3u w=1u l=0.28u
X36 start a_39308_6800# a_40508_6800# start pfet_03v3 ad=1.38p pd=4.76u as=0.65p ps=3.3u w=1u l=0.28u
X37 start a_16228_10824# a_16108_10960# start pfet_03v3 ad=1.38p pd=4.76u as=0.65p ps=3.3u w=1u l=0.28u
X38 start comp_out_p a_44908_50400# start nfet_03v3 ad=0.577p pd=3.52u as=0.2646p ps=2.1u w=0.42u l=0.28u
X39 start a_9308_15760# a_11708_15760# start pfet_03v3 ad=1.38p pd=4.76u as=0.65p ps=3.3u w=1u l=0.28u
X40 start a_41308_37600# a_43708_37600# start pfet_03v3 ad=1.38p pd=4.76u as=0.65p ps=3.3u w=1u l=0.28u
X41 start a_2908_37600# a_10108_37600# start pfet_03v3 ad=1.104p pd=4.36u as=0.52p ps=2.9u w=0.8u l=0.28u
X42 a_16108_15760# a_15028_15624# a_17308_15760# start nfet_03v3 ad=0.305p pd=2.22u as=0.305p ps=2.22u w=0.5u l=0.28u
X43 start a_53708_1200# a_54908_1200# start pfet_03v3 ad=1.38p pd=4.76u as=0.65p ps=3.3u w=1u l=0.28u
X44 start start a_17708_54400# start nfet_03v3 ad=0.577p pd=3.52u as=0.2646p ps=2.1u w=0.42u l=0.28u
X45 start a_17308_29600# a_19708_29600# start pfet_03v3 ad=1.38p pd=4.76u as=0.65p ps=3.3u w=1u l=0.28u
X46 start a_47828_9464# a_46628_9464# start nfet_03v3 ad=0.66p pd=3.64u as=0.305p ps=2.22u w=0.5u l=0.28u
X47 start a_2908_46000# a_4108_46000# start pfet_03v3 ad=1.38p pd=4.76u as=0.65p ps=3.3u w=1u l=0.28u
X48 start a_19708_46000# a_20908_46000# start nfet_03v3 ad=0.66p pd=3.64u as=0.305p ps=2.22u w=0.5u l=0.28u
X49 start dout[5] a_49708_33600# start pfet_03v3 ad=1.104p pd=4.36u as=0.52p ps=2.9u w=0.8u l=0.28u
X50 start a_50508_54400# dac_in[7] start pfet_03v3 ad=1.38p pd=4.76u as=0.65p ps=3.3u w=1u l=0.28u
X51 start a_11308_37600# a_12694_36400# start nfet_03v3 ad=0.66p pd=3.64u as=0.305p ps=2.22u w=0.5u l=0.28u
X52 start comp_out_p comp_out_p start nfet_03v3 ad=0.66p pd=3.64u as=0.305p ps=2.22u w=0.5u l=0.28u
X53 a_43894_40400# a_41308_41600# a_43708_41600# start nfet_03v3 ad=0.305p pd=2.22u as=0.305p ps=2.22u w=0.5u l=0.28u
X54 start a_59828_15064# a_58628_15064# start pfet_03v3 ad=1.38p pd=4.76u as=0.65p ps=3.3u w=1u l=0.28u
X55 start a_33308_12400# a_34508_12400# start nfet_03v3 ad=0.66p pd=3.64u as=0.305p ps=2.22u w=0.5u l=0.28u
X56 start start a_30228_54264# start pfet_03v3 ad=1.38p pd=4.76u as=0.65p ps=3.3u w=1u l=0.28u
X57 start a_2908_41600# a_10108_41600# start nfet_03v3 ad=0.577p pd=3.52u as=0.2646p ps=2.1u w=0.42u l=0.28u
X58 start a_54908_6800# a_56108_6800# start nfet_03v3 ad=0.66p pd=3.64u as=0.305p ps=2.22u w=0.5u l=0.28u
X59 start start a_4108_54400# start pfet_03v3 ad=1.104p pd=4.36u as=0.52p ps=2.9u w=0.8u l=0.28u
X60 a_19894_32400# a_17308_33600# a_19708_33600# start nfet_03v3 ad=0.305p pd=2.22u as=0.305p ps=2.22u w=0.5u l=0.28u
X61 start a_39308_1200# a_40508_1200# start pfet_03v3 ad=1.38p pd=4.76u as=0.65p ps=3.3u w=1u l=0.28u
X62 start a_5708_6160# a_4508_6160# start nfet_03v3 ad=0.577p pd=3.52u as=0.2646p ps=2.1u w=0.42u l=2.4u
X63 start a_17308_15760# a_18508_15760# start pfet_03v3 ad=1.38p pd=4.76u as=0.65p ps=3.3u w=1u l=0.28u
X64 start a_44108_6800# a_45308_6800# start pfet_03v3 ad=1.38p pd=4.76u as=0.65p ps=3.3u w=1u l=0.28u
X65 start a_12508_46000# a_13708_46000# start nfet_03v3 ad=0.66p pd=3.64u as=0.305p ps=2.22u w=0.5u l=0.28u
X66 start a_47708_12400# a_48908_12400# start pfet_03v3 ad=1.38p pd=4.76u as=0.65p ps=3.3u w=1u l=0.28u
X67 start dac_in[0] dac_in[0] start nfet_03v3 ad=0.577p pd=3.52u as=0.2646p ps=2.1u w=0.42u l=0.28u
X68 start a_34108_37600# a_41308_37600# start nfet_03v3 ad=0.577p pd=3.52u as=0.2646p ps=2.1u w=0.42u l=0.28u
X69 start a_33308_24800# sample_en start pfet_03v3 ad=1.38p pd=4.76u as=0.65p ps=3.3u w=1u l=0.28u
X70 start a_9708_54400# dac_in[1] start pfet_03v3 ad=1.38p pd=4.76u as=0.65p ps=3.3u w=1u l=0.28u
X71 start a_23428_54264# a_23308_54400# start pfet_03v3 ad=1.104p pd=4.36u as=0.52p ps=2.9u w=0.8u l=0.28u
X72 start a_51708_50400# a_53094_49200# start nfet_03v3 ad=0.66p pd=3.64u as=0.305p ps=2.22u w=0.5u l=0.28u
X73 start comp_out_p a_17308_29600# start nfet_03v3 ad=0.577p pd=3.52u as=0.2646p ps=2.1u w=0.42u l=0.28u
X74 start a_3428_1424# start start nfet_03v3 ad=0.305p pd=2.22u as=0.40951n ps=2.30248m w=0.5u l=0.28u
X75 start a_40508_6800# a_41708_6800# start nfet_03v3 ad=0.66p pd=3.64u as=0.305p ps=2.22u w=0.5u l=0.28u
X76 start a_35708_1200# a_36908_1200# start nfet_03v3 ad=0.66p pd=3.64u as=0.305p ps=2.22u w=0.5u l=0.28u
X77 a_5494_49200# a_2908_50400# a_3028_54264# start nfet_03v3 ad=0.305p pd=2.22u as=0.305p ps=2.22u w=0.5u l=0.28u
X78 start a_50108_12400# a_51308_12400# start pfet_03v3 ad=1.38p pd=4.76u as=0.65p ps=3.3u w=1u l=0.28u
X79 start a_57428_15064# a_56228_15064# start nfet_03v3 ad=0.66p pd=3.64u as=0.305p ps=2.22u w=0.5u l=0.28u
X80 start a_35308_29600# comp_out_p start pfet_03v3 ad=1.38p pd=4.76u as=0.65p ps=3.3u w=1u l=0.28u
X81 start a_44108_1200# a_45308_1200# start pfet_03v3 ad=1.38p pd=4.76u as=0.65p ps=3.3u w=1u l=0.28u
X82 start a_7708_41600# a_17308_41600# start pfet_03v3 ad=1.104p pd=4.36u as=0.52p ps=2.9u w=0.8u l=0.28u
X83 start start start start pfet_03v3 ad=0.65p pd=3.3u as=0.40171n ps=2.32842m w=1u l=0.28u
X84 start a_42508_29600# a_43894_28400# start nfet_03v3 ad=0.66p pd=3.64u as=0.305p ps=2.22u w=0.5u l=0.28u
X85 start start start start pfet_03v3 ad=0.65p pd=3.3u as=0 ps=0 w=1u l=0.28u
X86 start a_54908_1200# a_56108_1200# start nfet_03v3 ad=0.66p pd=3.64u as=0.305p ps=2.22u w=0.5u l=0.28u
X87 start a_50228_3864# a_49028_3864# start nfet_03v3 ad=0.66p pd=3.64u as=0.305p ps=2.22u w=0.5u l=0.28u
X88 start a_16508_54400# dac_in[2] start pfet_03v3 ad=1.38p pd=4.76u as=0.65p ps=3.3u w=1u l=0.28u
X89 start sample_en a_35708_24800# start pfet_03v3 ad=1.38p pd=4.76u as=0.65p ps=3.3u w=1u l=0.28u
X90 start a_46628_15064# a_45428_15064# start pfet_03v3 ad=1.38p pd=4.76u as=0.65p ps=3.3u w=1u l=0.28u
X91 start comp_out_p a_24508_50400# start nfet_03v3 ad=0.577p pd=3.52u as=0.2646p ps=2.1u w=0.42u l=0.28u
X92 start a_10908_50400# a_12294_49200# start nfet_03v3 ad=0.66p pd=3.64u as=0.305p ps=2.22u w=0.5u l=0.28u
X93 start a_8908_46000# a_10108_46000# start pfet_03v3 ad=1.38p pd=4.76u as=0.65p ps=3.3u w=1u l=0.28u
X94 start comp_out_p a_48508_37600# start pfet_03v3 ad=1.104p pd=4.36u as=0.52p ps=2.9u w=0.8u l=0.28u
X95 start a_47028_19064# done start nfet_03v3 ad=0.66p pd=3.64u as=0.305p ps=2.22u w=0.5u l=0.28u
X96 start start a_34108_29600# start pfet_03v3 ad=1.38p pd=4.76u as=0.65p ps=3.3u w=1u l=0.28u
X97 start a_45308_1200# a_46508_1200# start nfet_03v3 ad=0.66p pd=3.64u as=0.305p ps=2.22u w=0.5u l=0.28u
X98 start a_45308_6800# a_46508_6800# start nfet_03v3 ad=0.66p pd=3.64u as=0.305p ps=2.22u w=0.5u l=0.28u
X99 start a_12508_37600# dout[2] start pfet_03v3 ad=1.104p pd=4.36u as=0.52p ps=2.9u w=0.8u l=0.28u
X100 start a_18508_6160# a_17308_6160# start pfet_03v3 ad=0.6034p pd=3.64u as=0.2822p ps=2.18u w=0.42u l=2u
X101 start a_34508_6800# a_35708_6800# start pfet_03v3 ad=1.38p pd=4.76u as=0.65p ps=3.3u w=1u l=0.28u
X102 start a_42508_41600# a_43708_41600# start pfet_03v3 ad=1.38p pd=4.76u as=0.65p ps=3.3u w=1u l=0.28u
X103 start a_7708_46000# a_8908_46000# start pfet_03v3 ad=1.38p pd=4.76u as=0.65p ps=3.3u w=1u l=0.28u
X104 start a_50228_9464# a_49028_9464# start nfet_03v3 ad=0.66p pd=3.64u as=0.305p ps=2.22u w=0.5u l=0.28u
X105 start comp_out_p comp_out_p start pfet_03v3 ad=1.38p pd=4.76u as=0.65p ps=3.3u w=1u l=0.28u
X106 start start dac_in[4] start pfet_03v3 ad=1.38p pd=4.76u as=0.65p ps=3.3u w=1u l=0.28u
X107 start a_43828_54264# a_43708_54400# start pfet_03v3 ad=1.104p pd=4.36u as=0.52p ps=2.9u w=0.8u l=0.28u
X108 a_20908_1360# a_17308_1360# a_23308_1360# start nfet_03v3 ad=0.305p pd=2.22u as=0.305p ps=2.22u w=0.5u l=0.28u
X109 start dac_in[2] dac_in[2] start pfet_03v3 ad=1.104p pd=4.36u as=0.52p ps=2.9u w=0.8u l=0.28u
X110 start comp_out_p comp_out_p start pfet_03v3 ad=1.38p pd=4.76u as=0.65p ps=3.3u w=1u l=0.28u
X111 start a_23428_10824# a_22108_10960# start pfet_03v3 ad=1.38p pd=4.76u as=0.65p ps=3.3u w=1u l=0.28u
X112 start dout[2] a_18508_37600# start nfet_03v3 ad=0.577p pd=3.52u as=0.2646p ps=2.1u w=0.42u l=0.28u
X113 start start a_40908_24800# start pfet_03v3 ad=1.104p pd=4.36u as=0.52p ps=2.9u w=0.8u l=0.28u
X114 start a_38908_41600# a_48508_41600# start nfet_03v3 ad=0.577p pd=3.52u as=0.2646p ps=2.1u w=0.42u l=0.28u
X115 start start a_34108_33600# start nfet_03v3 ad=0.66p pd=3.64u as=0.305p ps=2.22u w=0.5u l=0.28u
X116 start a_55028_3864# a_53828_3864# start nfet_03v3 ad=0.66p pd=3.64u as=0.305p ps=2.22u w=0.5u l=0.28u
X117 start a_12508_41600# dout[3] start nfet_03v3 ad=0.577p pd=3.52u as=0.2646p ps=2.1u w=0.42u l=0.28u
X118 start a_3428_1424# start start pfet_03v3 ad=0.65p pd=3.3u as=0 ps=0 w=1u l=0.28u
X119 start a_38108_12400# a_39308_12400# start nfet_03v3 ad=0.66p pd=3.64u as=0.305p ps=2.22u w=0.5u l=0.28u
X120 start a_22108_15760# a_24508_15760# start nfet_03v3 ad=0.66p pd=3.64u as=0.305p ps=2.22u w=0.5u l=0.28u
X121 start comp_out_p comp_out_p start nfet_03v3 ad=0.66p pd=3.64u as=0.305p ps=2.22u w=0.5u l=0.28u
X122 start done a_33308_24800# start nfet_03v3 ad=0.66p pd=3.64u as=0.305p ps=2.22u w=0.5u l=0.28u
X123 start rst_latch rst_latch start nfet_03v3 ad=0.577p pd=3.52u as=0.2646p ps=2.1u w=0.42u l=0.28u
X124 start a_44228_15064# a_44108_15200# start nfet_03v3 ad=0.66p pd=3.64u as=0.305p ps=2.22u w=0.5u l=0.28u
X125 start a_17308_46000# a_18508_46000# start nfet_03v3 ad=0.66p pd=3.64u as=0.305p ps=2.22u w=0.5u l=0.28u
X126 start a_34508_1200# a_35708_1200# start pfet_03v3 ad=1.38p pd=4.76u as=0.65p ps=3.3u w=1u l=0.28u
X127 start a_10628_6024# a_9494_4800# start nfet_03v3 ad=0.66p pd=3.64u as=0.305p ps=2.22u w=0.5u l=0.28u
X128 start a_43708_37600# dout[6] start nfet_03v3 ad=0.577p pd=3.52u as=0.2646p ps=2.1u w=0.42u l=0.28u
X129 start a_36908_54400# dac_in[5] start pfet_03v3 ad=1.38p pd=4.76u as=0.65p ps=3.3u w=1u l=0.28u
X130 start a_40628_3864# a_39428_3864# start nfet_03v3 ad=0.66p pd=3.64u as=0.305p ps=2.22u w=0.5u l=0.28u
X131 start a_15028_6024# a_14908_6160# start nfet_03v3 ad=0.66p pd=3.64u as=0.305p ps=2.22u w=0.5u l=0.28u
X132 start dac_in[3] dac_in[3] start pfet_03v3 ad=1.104p pd=4.36u as=0.52p ps=2.9u w=0.8u l=0.28u
X133 start a_55028_9464# a_53828_9464# start nfet_03v3 ad=0.66p pd=3.64u as=0.305p ps=2.22u w=0.5u l=0.28u
X134 start a_40508_12400# a_41708_12400# start nfet_03v3 ad=0.66p pd=3.64u as=0.305p ps=2.22u w=0.5u l=0.28u
X135 start start a_32694_49200# start nfet_03v3 ad=0.66p pd=3.64u as=0.305p ps=2.22u w=0.5u l=0.28u
X136 start a_44228_9464# a_43028_9464# start pfet_03v3 ad=1.38p pd=4.76u as=0.65p ps=3.3u w=1u l=0.28u
X137 start start a_4294_28400# start nfet_03v3 ad=0.66p pd=3.64u as=0.305p ps=2.22u w=0.5u l=0.28u
X138 start a_22108_15760# a_20908_15760# start pfet_03v3 ad=0.6034p pd=3.64u as=0.2822p ps=2.18u w=0.42u l=2u
X139 start a_2228_10824# a_2108_10960# start pfet_03v3 ad=1.38p pd=4.76u as=0.65p ps=3.3u w=1u l=0.28u
X140 a_3308_6160# a_2108_6160# a_4508_6160# start pfet_03v3 ad=0.65p pd=3.3u as=0.65p ps=3.3u w=1u l=0.28u
X141 start a_30228_54264# start start nfet_03v3 ad=0.2646p pd=2.1u as=0 ps=0 w=0.42u l=0.28u
X142 start comp_out_p comp_out_p start pfet_03v3 ad=1.38p pd=4.76u as=0.65p ps=3.3u w=1u l=0.28u
X143 start a_18508_29600# a_19708_29600# start pfet_03v3 ad=1.38p pd=4.76u as=0.65p ps=3.3u w=1u l=0.28u
X144 a_3308_20560# a_2108_20560# a_4508_20560# start pfet_03v3 ad=0.65p pd=3.3u as=0.65p ps=3.3u w=1u l=0.28u
X145 start a_48508_33600# a_50908_33600# start pfet_03v3 ad=1.38p pd=4.76u as=0.65p ps=3.3u w=1u l=0.28u
X146 start a_54908_12400# a_56108_12400# start pfet_03v3 ad=1.38p pd=4.76u as=0.65p ps=3.3u w=1u l=0.28u
X147 start a_3428_15624# a_3308_15760# start nfet_03v3 ad=0.66p pd=3.64u as=0.305p ps=2.22u w=0.5u l=0.28u
X148 start dac_in[5] dac_in[5] start pfet_03v3 ad=1.104p pd=4.36u as=0.52p ps=2.9u w=0.8u l=0.28u
X149 start a_61028_15064# a_59828_15064# start pfet_03v3 ad=1.38p pd=4.76u as=0.65p ps=3.3u w=1u l=0.28u
X150 start a_40628_9464# a_39428_9464# start nfet_03v3 ad=0.66p pd=3.64u as=0.305p ps=2.22u w=0.5u l=0.28u
X151 start comp_out_p a_4108_41600# start pfet_03v3 ad=1.38p pd=4.76u as=0.65p ps=3.3u w=1u l=0.28u
X152 a_20908_1360# start a_23308_1360# start pfet_03v3 ad=0.65p pd=3.3u as=0.65p ps=3.3u w=1u l=0.28u
X153 a_35494_40400# comp_out_p a_35308_41600# start nfet_03v3 ad=0.305p pd=2.22u as=0.305p ps=2.22u w=0.5u l=0.28u
X154 start a_58508_12400# a_59708_12400# start nfet_03v3 ad=0.66p pd=3.64u as=0.305p ps=2.22u w=0.5u l=0.28u
X155 start a_18508_33600# a_19894_32400# start nfet_03v3 ad=0.66p pd=3.64u as=0.305p ps=2.22u w=0.5u l=0.28u
X156 start a_13708_46000# a_14908_46000# start pfet_03v3 ad=1.38p pd=4.76u as=0.65p ps=3.3u w=1u l=0.28u
X157 start a_45428_3864# a_44228_3864# start nfet_03v3 ad=0.66p pd=3.64u as=0.305p ps=2.22u w=0.5u l=0.28u
X158 start a_37028_54264# a_36908_54400# start nfet_03v3 ad=0.577p pd=3.52u as=0.2646p ps=2.1u w=0.42u l=0.28u
X159 start a_11308_29600# a_12508_29600# start pfet_03v3 ad=1.38p pd=4.76u as=0.65p ps=3.3u w=1u l=0.28u
X160 start a_35308_29600# a_35308_29600# start pfet_03v3 ad=1.38p pd=4.76u as=0.65p ps=3.3u w=1u l=0.28u
X161 start a_44228_3864# a_43028_3864# start pfet_03v3 ad=1.38p pd=4.76u as=0.65p ps=3.3u w=1u l=0.28u
X162 start a_22108_6160# a_20908_6160# start nfet_03v3 ad=0.577p pd=3.52u as=0.2646p ps=2.1u w=0.42u l=2.4u
X163 start a_41308_33600# a_43708_33600# start pfet_03v3 ad=1.38p pd=4.76u as=0.65p ps=3.3u w=1u l=0.28u
X164 a_3308_15760# a_2108_15760# a_4508_15760# start pfet_03v3 ad=0.65p pd=3.3u as=0.65p ps=3.3u w=1u l=0.28u
X165 start start start start nfet_03v3 ad=0.305p pd=2.22u as=0 ps=0 w=0.5u l=0.28u
X166 start a_49028_9464# a_47828_9464# start pfet_03v3 ad=1.38p pd=4.76u as=0.65p ps=3.3u w=1u l=0.28u
X167 start start a_2908_37600# start pfet_03v3 ad=1.38p pd=4.76u as=0.65p ps=3.3u w=1u l=0.28u
X168 start a_2908_33600# a_10108_33600# start pfet_03v3 ad=1.104p pd=4.36u as=0.52p ps=2.9u w=0.8u l=0.28u
X169 start a_36908_1200# a_38108_1200# start nfet_03v3 ad=0.66p pd=3.64u as=0.305p ps=2.22u w=0.5u l=0.28u
X170 start a_20908_6160# a_22108_6160# start pfet_03v3 ad=1.38p pd=4.76u as=0.65p ps=3.3u w=1u l=0.28u
X171 start a_8108_6160# a_9308_6160# start pfet_03v3 ad=1.38p pd=4.76u as=0.65p ps=3.3u w=1u l=0.28u
X172 start a_49708_29600# a_51094_28400# start nfet_03v3 ad=0.66p pd=3.64u as=0.305p ps=2.22u w=0.5u l=0.28u
X173 start dac_in[6] dac_in[6] start pfet_03v3 ad=1.104p pd=4.36u as=0.52p ps=2.9u w=0.8u l=0.28u
X174 start a_4508_20560# a_5708_20560# start nfet_03v3 ad=0.66p pd=3.64u as=0.305p ps=2.22u w=0.5u l=0.28u
X175 start a_53828_15064# a_52628_15064# start pfet_03v3 ad=1.38p pd=4.76u as=0.65p ps=3.3u w=1u l=0.28u
X176 start a_50508_50400# a_50628_54264# start pfet_03v3 ad=1.38p pd=4.76u as=0.65p ps=3.3u w=1u l=0.28u
X177 start a_22108_10960# a_24508_10960# start nfet_03v3 ad=0.66p pd=3.64u as=0.305p ps=2.22u w=0.5u l=0.28u
X178 start a_11308_33600# a_12694_32400# start nfet_03v3 ad=0.66p pd=3.64u as=0.305p ps=2.22u w=0.5u l=0.28u
X179 start comp_out_p comp_out_p start nfet_03v3 ad=0.66p pd=3.64u as=0.305p ps=2.22u w=0.5u l=0.28u
X180 start a_50628_54264# a_50508_54400# start nfet_03v3 ad=0.577p pd=3.52u as=0.2646p ps=2.1u w=0.42u l=0.28u
X181 start a_34108_29600# a_41308_29600# start pfet_03v3 ad=1.104p pd=4.36u as=0.52p ps=2.9u w=0.8u l=0.28u
X182 a_43094_18000# start a_42908_19200# start nfet_03v3 ad=0.305p pd=2.22u as=0.305p ps=2.22u w=0.5u l=0.28u
X183 start a_56108_1200# a_57308_1200# start nfet_03v3 ad=0.66p pd=3.64u as=0.305p ps=2.22u w=0.5u l=0.28u
X184 start a_45428_9464# a_44228_9464# start nfet_03v3 ad=0.66p pd=3.64u as=0.305p ps=2.22u w=0.5u l=0.28u
X185 start a_19708_37600# dout[2] start pfet_03v3 ad=1.104p pd=4.36u as=0.52p ps=2.9u w=0.8u l=0.28u
X186 start a_24508_1360# a_23308_1360# start pfet_03v3 ad=0.6034p pd=3.64u as=0.2822p ps=2.18u w=0.42u l=2u
X187 start a_34628_9464# a_33428_9464# start pfet_03v3 ad=1.38p pd=4.76u as=0.65p ps=3.3u w=1u l=0.28u
X188 start a_49708_41600# a_50908_41600# start pfet_03v3 ad=1.38p pd=4.76u as=0.65p ps=3.3u w=1u l=0.28u
X189 start start a_2908_41600# start nfet_03v3 ad=0.66p pd=3.64u as=0.305p ps=2.22u w=0.5u l=0.28u
X190 start start a_4108_50400# start pfet_03v3 ad=1.104p pd=4.36u as=0.52p ps=2.9u w=0.8u l=0.28u
X191 start a_41708_12400# a_42908_12400# start pfet_03v3 ad=1.38p pd=4.76u as=0.65p ps=3.3u w=1u l=0.28u
X192 start a_49028_15064# a_47828_15064# start nfet_03v3 ad=0.66p pd=3.64u as=0.305p ps=2.22u w=0.5u l=0.28u
X193 start a_49028_3864# sample_en start pfet_03v3 ad=1.38p pd=4.76u as=0.65p ps=3.3u w=1u l=0.28u
X194 start a_5308_46000# a_6508_46000# start nfet_03v3 ad=0.66p pd=3.64u as=0.305p ps=2.22u w=0.5u l=0.28u
X195 start dout[0] a_11308_29600# start nfet_03v3 ad=0.577p pd=3.52u as=0.2646p ps=2.1u w=0.42u l=0.28u
X196 start a_46508_1200# a_47708_1200# start nfet_03v3 ad=0.66p pd=3.64u as=0.305p ps=2.22u w=0.5u l=0.28u
X197 start a_59828_9464# a_58628_9464# start pfet_03v3 ad=1.38p pd=4.76u as=0.65p ps=3.3u w=1u l=0.28u
X198 start a_34108_33600# a_41308_33600# start nfet_03v3 ad=0.577p pd=3.52u as=0.2646p ps=2.1u w=0.42u l=0.28u
X199 start a_10628_20424# a_9308_20560# start pfet_03v3 ad=1.38p pd=4.76u as=0.65p ps=3.3u w=1u l=0.28u
X200 start a_41708_6800# a_42908_6800# start pfet_03v3 ad=1.38p pd=4.76u as=0.65p ps=3.3u w=1u l=0.28u
X201 start a_19708_41600# dout[3] start nfet_03v3 ad=0.577p pd=3.52u as=0.2646p ps=2.1u w=0.42u l=0.28u
X202 start a_45308_12400# a_46508_12400# start nfet_03v3 ad=0.66p pd=3.64u as=0.305p ps=2.22u w=0.5u l=0.28u
X203 start a_9708_50400# a_9828_54264# start pfet_03v3 ad=1.38p pd=4.76u as=0.65p ps=3.3u w=1u l=0.28u
X204 start dout[3] a_23308_50400# start pfet_03v3 ad=1.104p pd=4.36u as=0.52p ps=2.9u w=0.8u l=0.28u
X205 a_24694_0# a_23308_1360# a_24508_1360# start nfet_03v3 ad=0.305p pd=2.22u as=0.305p ps=2.22u w=0.5u l=0.28u
X206 start start a_33308_24800# start nfet_03v3 ad=0.66p pd=3.64u as=0.305p ps=2.22u w=0.5u l=0.28u
X207 start a_5708_10960# a_4508_10960# start pfet_03v3 ad=0.6034p pd=3.64u as=0.2822p ps=2.18u w=0.42u l=2u
X208 start dac_in[4] dac_in[4] start nfet_03v3 ad=0.577p pd=3.52u as=0.2646p ps=2.1u w=0.42u l=0.28u
X209 a_46294_53200# a_43708_54400# dac_in[6] start nfet_03v3 ad=0.305p pd=2.22u as=0.305p ps=2.22u w=0.5u l=0.28u
X210 start a_8108_20560# a_9308_20560# start pfet_03v3 ad=1.38p pd=4.76u as=0.65p ps=3.3u w=1u l=0.28u
X211 start a_51428_15064# a_50228_15064# start nfet_03v3 ad=0.66p pd=3.64u as=0.305p ps=2.22u w=0.5u l=0.28u
X212 start a_35828_3864# a_34628_3864# start nfet_03v3 ad=0.66p pd=3.64u as=0.305p ps=2.22u w=0.5u l=0.28u
X213 start dout[3] a_11308_41600# start pfet_03v3 ad=1.104p pd=4.36u as=0.52p ps=2.9u w=0.8u l=0.28u
X214 a_5708_15760# a_2108_15760# a_8108_15760# start nfet_03v3 ad=0.305p pd=2.22u as=0.305p ps=2.22u w=0.5u l=0.28u
X215 start a_34628_3864# a_33428_3864# start pfet_03v3 ad=1.38p pd=4.76u as=0.65p ps=3.3u w=1u l=0.28u
X216 start a_34508_12400# a_35708_12400# start pfet_03v3 ad=1.38p pd=4.76u as=0.65p ps=3.3u w=1u l=0.28u
X217 start a_50908_37600# dout[6] start nfet_03v3 ad=0.577p pd=3.52u as=0.2646p ps=2.1u w=0.42u l=0.28u
X218 start a_39428_9464# a_38228_9464# start pfet_03v3 ad=1.38p pd=4.76u as=0.65p ps=3.3u w=1u l=0.28u
X219 start a_15028_10824# a_14908_10960# start pfet_03v3 ad=1.38p pd=4.76u as=0.65p ps=3.3u w=1u l=0.28u
X220 start dout[6] a_42508_37600# start pfet_03v3 ad=1.104p pd=4.36u as=0.52p ps=2.9u w=0.8u l=0.28u
X221 start a_10628_15624# a_9308_15760# start pfet_03v3 ad=1.38p pd=4.76u as=0.65p ps=3.3u w=1u l=0.28u
X222 start a_59828_3864# a_58628_3864# start pfet_03v3 ad=1.38p pd=4.76u as=0.65p ps=3.3u w=1u l=0.28u
X223 start a_16508_50400# a_16628_54264# start pfet_03v3 ad=1.38p pd=4.76u as=0.65p ps=3.3u w=1u l=0.28u
X224 start a_41708_1200# a_42908_1200# start pfet_03v3 ad=1.38p pd=4.76u as=0.65p ps=3.3u w=1u l=0.28u
X225 start a_16228_15624# a_16108_15760# start nfet_03v3 ad=0.66p pd=3.64u as=0.305p ps=2.22u w=0.5u l=0.28u
X226 start a_16628_54264# a_16508_54400# start nfet_03v3 ad=0.577p pd=3.52u as=0.2646p ps=2.1u w=0.42u l=0.28u
X227 start dout[0] a_18508_29600# start pfet_03v3 ad=1.104p pd=4.36u as=0.52p ps=2.9u w=0.8u l=0.28u
X228 start a_35828_9464# a_34628_9464# start nfet_03v3 ad=0.66p pd=3.64u as=0.305p ps=2.22u w=0.5u l=0.28u
X229 start comp_done a_2908_46000# start pfet_03v3 ad=1.38p pd=4.76u as=0.65p ps=3.3u w=1u l=0.28u
X230 start comp_out_p a_48508_33600# start pfet_03v3 ad=1.104p pd=4.36u as=0.52p ps=2.9u w=0.8u l=0.28u
X231 start a_8108_15760# a_9308_15760# start pfet_03v3 ad=1.38p pd=4.76u as=0.65p ps=3.3u w=1u l=0.28u
X232 start a_2228_1424# start start pfet_03v3 ad=0.52p pd=2.9u as=0 ps=0 w=0.8u l=0.28u
X233 start a_18628_1224# a_18508_1360# start pfet_03v3 ad=1.38p pd=4.76u as=0.65p ps=3.3u w=1u l=0.28u
X234 start a_52508_6800# a_53708_6800# start pfet_03v3 ad=1.38p pd=4.76u as=0.65p ps=3.3u w=1u l=0.28u
X235 start a_9308_20560# a_11708_20560# start nfet_03v3 ad=0.66p pd=3.64u as=0.305p ps=2.22u w=0.5u l=0.28u
X236 start a_12508_33600# dout[1] start pfet_03v3 ad=1.104p pd=4.36u as=0.52p ps=2.9u w=0.8u l=0.28u
X237 a_12694_36400# a_10108_37600# a_12508_37600# start nfet_03v3 ad=0.305p pd=2.22u as=0.305p ps=2.22u w=0.5u l=0.28u
X238 start dout[7] a_42508_41600# start nfet_03v3 ad=0.577p pd=3.52u as=0.2646p ps=2.1u w=0.42u l=0.28u
X239 start a_58628_15064# a_57428_15064# start pfet_03v3 ad=1.38p pd=4.76u as=0.65p ps=3.3u w=1u l=0.28u
X240 start a_39428_3864# a_38228_3864# start pfet_03v3 ad=1.38p pd=4.76u as=0.65p ps=3.3u w=1u l=0.28u
X241 start start a_30228_54264# start pfet_03v3 ad=1.38p pd=4.76u as=0.65p ps=3.3u w=1u l=0.28u
X242 start dout[6] a_43708_50400# start pfet_03v3 ad=1.104p pd=4.36u as=0.52p ps=2.9u w=0.8u l=0.28u
X243 start a_33428_12264# a_33308_12400# start nfet_03v3 ad=0.66p pd=3.64u as=0.305p ps=2.22u w=0.5u l=0.28u
X244 start a_3028_54264# a_2908_54400# start pfet_03v3 ad=1.104p pd=4.36u as=0.52p ps=2.9u w=0.8u l=0.28u
X245 start a_16628_54264# a_16628_54264# start pfet_03v3 ad=1.104p pd=4.36u as=0.52p ps=2.9u w=0.8u l=0.28u
X246 start a_42908_6800# a_44108_6800# start nfet_03v3 ad=0.66p pd=3.64u as=0.305p ps=2.22u w=0.5u l=0.28u
X247 start dac_in[7] dac_in[7] start nfet_03v3 ad=0.577p pd=3.52u as=0.2646p ps=2.1u w=0.42u l=0.28u
X248 start dout[1] a_18508_33600# start nfet_03v3 ad=0.577p pd=3.52u as=0.2646p ps=2.1u w=0.42u l=0.28u
X249 a_16108_6160# a_14908_6160# a_17308_6160# start pfet_03v3 ad=0.65p pd=3.3u as=0.65p ps=3.3u w=1u l=0.28u
X250 start a_33428_6664# a_33308_6800# start pfet_03v3 ad=1.38p pd=4.76u as=0.65p ps=3.3u w=1u l=0.28u
X251 start a_43708_29600# dout[4] start pfet_03v3 ad=1.104p pd=4.36u as=0.52p ps=2.9u w=0.8u l=0.28u
X252 a_16108_15760# a_14908_15760# a_17308_15760# start pfet_03v3 ad=0.65p pd=3.3u as=0.65p ps=3.3u w=1u l=0.28u
X253 start a_11308_46000# a_12508_46000# start nfet_03v3 ad=0.66p pd=3.64u as=0.305p ps=2.22u w=0.5u l=0.28u
X254 start a_47708_1200# a_48908_1200# start nfet_03v3 ad=0.66p pd=3.64u as=0.305p ps=2.22u w=0.5u l=0.28u
X255 start a_18508_10960# a_17308_10960# start nfet_03v3 ad=0.577p pd=3.52u as=0.2646p ps=2.1u w=0.42u l=2.4u
X256 start a_4108_54400# a_5494_53200# start nfet_03v3 ad=0.66p pd=3.64u as=0.305p ps=2.22u w=0.5u l=0.28u
X257 start dout[4] a_49708_29600# start nfet_03v3 ad=0.577p pd=3.52u as=0.2646p ps=2.1u w=0.42u l=0.28u
X258 start start start start pfet_03v3 ad=0.65p pd=3.3u as=0 ps=0 w=1u l=0.28u
X259 start a_52508_1200# a_53708_1200# start pfet_03v3 ad=1.38p pd=4.76u as=0.65p ps=3.3u w=1u l=0.28u
X260 start a_3428_1424# start start nfet_03v3 ad=0.305p pd=2.22u as=0 ps=0 w=0.5u l=0.28u
X261 start start a_10908_54400# start pfet_03v3 ad=1.104p pd=4.36u as=0.52p ps=2.9u w=0.8u l=0.28u
X262 start a_57308_6800# a_58508_6800# start pfet_03v3 ad=1.38p pd=4.76u as=0.65p ps=3.3u w=1u l=0.28u
X263 start a_9308_10960# a_8108_10960# start pfet_03v3 ad=0.6034p pd=3.64u as=0.2822p ps=2.18u w=0.42u l=2u
X264 start a_59708_12400# a_60908_12400# start nfet_03v3 ad=0.66p pd=3.64u as=0.305p ps=2.22u w=0.5u l=0.28u
X265 a_53094_49200# a_50508_50400# a_50628_54264# start nfet_03v3 ad=0.305p pd=2.22u as=0.305p ps=2.22u w=0.5u l=0.28u
X266 start a_43708_33600# dout[5] start nfet_03v3 ad=0.577p pd=3.52u as=0.2646p ps=2.1u w=0.42u l=0.28u
X267 start a_38108_1200# a_39308_1200# start nfet_03v3 ad=0.66p pd=3.64u as=0.305p ps=2.22u w=0.5u l=0.28u
X268 start a_23428_54264# a_23428_54264# start pfet_03v3 ad=1.104p pd=4.36u as=0.52p ps=2.9u w=0.8u l=0.28u
X269 start a_36908_50400# a_37028_54264# start pfet_03v3 ad=1.38p pd=4.76u as=0.65p ps=3.3u w=1u l=0.28u
X270 start dac_in[1] dac_in[1] start nfet_03v3 ad=0.577p pd=3.52u as=0.2646p ps=2.1u w=0.42u l=0.28u
X271 a_25894_53200# a_23308_54400# dac_in[3] start nfet_03v3 ad=0.305p pd=2.22u as=0.305p ps=2.22u w=0.5u l=0.28u
X272 start start a_4108_50400# start nfet_03v3 ad=0.577p pd=3.52u as=0.2646p ps=2.1u w=0.42u l=0.28u
X273 start a_17308_37600# a_19708_37600# start pfet_03v3 ad=1.38p pd=4.76u as=0.65p ps=3.3u w=1u l=0.28u
X274 start a_48908_12400# a_50108_12400# start pfet_03v3 ad=1.38p pd=4.76u as=0.65p ps=3.3u w=1u l=0.28u
X275 start a_56228_15064# a_55028_15064# start nfet_03v3 ad=0.66p pd=3.64u as=0.305p ps=2.22u w=0.5u l=0.28u
X276 start dout[7] a_49708_41600# start pfet_03v3 ad=1.104p pd=4.36u as=0.52p ps=2.9u w=0.8u l=0.28u
X277 start start a_33308_1200# start pfet_03v3 ad=1.38p pd=4.76u as=0.65p ps=3.3u w=1u l=0.28u
X278 start a_47708_6800# a_48908_6800# start nfet_03v3 ad=0.66p pd=3.64u as=0.305p ps=2.22u w=0.5u l=0.28u
X279 start comp_out_p comp_out_p start pfet_03v3 ad=1.38p pd=4.76u as=0.65p ps=3.3u w=1u l=0.28u
X280 start a_36908_6800# a_38108_6800# start pfet_03v3 ad=1.38p pd=4.76u as=0.65p ps=3.3u w=1u l=0.28u
X281 start a_57308_1200# a_58508_1200# start nfet_03v3 ad=0.66p pd=3.64u as=0.305p ps=2.22u w=0.5u l=0.28u
X282 start a_4508_6160# a_5708_6160# start nfet_03v3 ad=0.66p pd=3.64u as=0.305p ps=2.22u w=0.5u l=0.28u
X283 start a_2228_6024# a_2108_6160# start pfet_03v3 ad=1.38p pd=4.76u as=0.65p ps=3.3u w=1u l=0.28u
X284 start a_52508_12400# a_53708_12400# start nfet_03v3 ad=0.66p pd=3.64u as=0.305p ps=2.22u w=0.5u l=0.28u
X285 start a_37028_54264# a_37028_54264# start pfet_03v3 ad=1.104p pd=4.36u as=0.52p ps=2.9u w=0.8u l=0.28u
X286 start a_45428_15064# a_44228_15064# start pfet_03v3 ad=1.38p pd=4.76u as=0.65p ps=3.3u w=1u l=0.28u
X287 start dout[3] a_23308_50400# start nfet_03v3 ad=0.577p pd=3.52u as=0.2646p ps=2.1u w=0.42u l=0.28u
X288 a_12294_49200# a_9708_50400# a_9828_54264# start nfet_03v3 ad=0.305p pd=2.22u as=0.305p ps=2.22u w=0.5u l=0.28u
X289 a_19894_40400# a_17308_41600# a_19708_41600# start nfet_03v3 ad=0.305p pd=2.22u as=0.305p ps=2.22u w=0.5u l=0.28u
X290 start a_57308_1200# a_58508_1200# start pfet_03v3 ad=1.38p pd=4.76u as=0.65p ps=3.3u w=1u l=0.28u
X291 start a_33308_6800# a_34508_6800# start nfet_03v3 ad=0.66p pd=3.64u as=0.305p ps=2.22u w=0.5u l=0.28u
X292 a_3308_10960# a_2228_10824# a_4508_10960# start nfet_03v3 ad=0.305p pd=2.22u as=0.305p ps=2.22u w=0.5u l=0.28u
X293 start a_25828_1224# a_24694_0# start nfet_03v3 ad=0.66p pd=3.64u as=0.305p ps=2.22u w=0.5u l=0.28u
X294 start a_19708_1360# a_20908_1360# start pfet_03v3 ad=1.38p pd=4.76u as=0.65p ps=3.3u w=1u l=0.28u
X295 start a_17708_54400# dac_in[2] start pfet_03v3 ad=1.38p pd=4.76u as=0.65p ps=3.3u w=1u l=0.28u
X296 start start start start pfet_03v3 ad=0.52p pd=2.9u as=0 ps=0 w=0.8u l=0.28u
X297 start start a_35494_28400# start nfet_03v3 ad=0.66p pd=3.64u as=0.305p ps=2.22u w=0.5u l=0.28u
X298 start a_20908_10960# a_22108_10960# start pfet_03v3 ad=1.38p pd=4.76u as=0.65p ps=3.3u w=1u l=0.28u
X299 start comp_out_p a_17308_37600# start nfet_03v3 ad=0.577p pd=3.52u as=0.2646p ps=2.1u w=0.42u l=0.28u
X300 start start a_2908_33600# start pfet_03v3 ad=1.38p pd=4.76u as=0.65p ps=3.3u w=1u l=0.28u
X301 start a_36908_1200# a_38108_1200# start pfet_03v3 ad=1.38p pd=4.76u as=0.65p ps=3.3u w=1u l=0.28u
X302 start a_9308_6160# a_8108_6160# start nfet_03v3 ad=0.577p pd=3.52u as=0.2646p ps=2.1u w=0.42u l=2.4u
X303 start a_58508_6800# a_59708_6800# start nfet_03v3 ad=0.66p pd=3.64u as=0.305p ps=2.22u w=0.5u l=0.28u
X304 start a_43028_3864# a_41828_3864# start nfet_03v3 ad=0.66p pd=3.64u as=0.305p ps=2.22u w=0.5u l=0.28u
X305 start a_43828_54264# a_43828_54264# start pfet_03v3 ad=1.104p pd=4.36u as=0.52p ps=2.9u w=0.8u l=0.28u
X306 start a_23428_6024# a_22294_4800# start nfet_03v3 ad=0.66p pd=3.64u as=0.305p ps=2.22u w=0.5u l=0.28u
X307 start a_36908_12400# a_38108_12400# start nfet_03v3 ad=0.66p pd=3.64u as=0.305p ps=2.22u w=0.5u l=0.28u
X308 a_19094_49200# a_16508_50400# a_16628_54264# start nfet_03v3 ad=0.305p pd=2.22u as=0.305p ps=2.22u w=0.5u l=0.28u
X309 start a_23428_15624# a_22294_14400# start nfet_03v3 ad=0.66p pd=3.64u as=0.305p ps=2.22u w=0.5u l=0.28u
X310 start a_5708_6160# a_4508_6160# start pfet_03v3 ad=0.6034p pd=3.64u as=0.2822p ps=2.18u w=0.42u l=2u
X311 start a_52628_9464# a_51428_9464# start pfet_03v3 ad=1.38p pd=4.76u as=0.65p ps=3.3u w=1u l=0.28u
X312 start a_40908_24800# a_42294_23600# start nfet_03v3 ad=0.66p pd=3.64u as=0.305p ps=2.22u w=0.5u l=0.28u
X313 start a_16108_46000# a_17308_46000# start nfet_03v3 ad=0.66p pd=3.64u as=0.305p ps=2.22u w=0.5u l=0.28u
X314 start comp_out_p a_35308_41600# start pfet_03v3 ad=1.38p pd=4.76u as=0.65p ps=3.3u w=1u l=0.28u
X315 start a_19708_33600# dout[1] start pfet_03v3 ad=1.104p pd=4.36u as=0.52p ps=2.9u w=0.8u l=0.28u
X316 start start start start nfet_03v3 ad=0.305p pd=2.22u as=0 ps=0 w=0.5u l=0.28u
X317 start a_42508_37600# a_43894_36400# start nfet_03v3 ad=0.66p pd=3.64u as=0.305p ps=2.22u w=0.5u l=0.28u
X318 start a_38108_6800# a_39308_6800# start nfet_03v3 ad=0.66p pd=3.64u as=0.305p ps=2.22u w=0.5u l=0.28u
X319 a_9494_9600# a_8108_10960# a_9308_10960# start nfet_03v3 ad=0.305p pd=2.22u as=0.305p ps=2.22u w=0.5u l=0.28u
X320 a_22294_9600# a_20908_10960# a_22108_10960# start nfet_03v3 ad=0.305p pd=2.22u as=0.305p ps=2.22u w=0.5u l=0.28u
X321 start a_24508_54400# dac_in[3] start pfet_03v3 ad=1.38p pd=4.76u as=0.65p ps=3.3u w=1u l=0.28u
X322 start start a_38108_54400# start pfet_03v3 ad=1.104p pd=4.36u as=0.52p ps=2.9u w=0.8u l=0.28u
X323 start dout[6] a_43708_50400# start nfet_03v3 ad=0.577p pd=3.52u as=0.2646p ps=2.1u w=0.42u l=0.28u
X324 start a_43028_9464# a_41828_9464# start nfet_03v3 ad=0.66p pd=3.64u as=0.305p ps=2.22u w=0.5u l=0.28u
X325 start a_39308_12400# a_40508_12400# start nfet_03v3 ad=0.66p pd=3.64u as=0.305p ps=2.22u w=0.5u l=0.28u
X326 start a_16628_54264# a_16628_54264# start nfet_03v3 ad=0.577p pd=3.52u as=0.2646p ps=2.1u w=0.42u l=0.28u
X327 a_32694_49200# start a_30228_54264# start nfet_03v3 ad=0.305p pd=2.22u as=0.305p ps=2.22u w=0.5u l=0.28u
X328 start a_59708_6800# a_60908_6800# start pfet_03v3 ad=1.38p pd=4.76u as=0.65p ps=3.3u w=1u l=0.28u
X329 start a_50908_29600# dout[4] start pfet_03v3 ad=1.104p pd=4.36u as=0.52p ps=2.9u w=0.8u l=0.28u
X330 a_4294_28400# comp_out_p comp_out_p start nfet_03v3 ad=0.305p pd=2.22u as=0.305p ps=2.22u w=0.5u l=0.28u
X331 start a_22108_15760# a_24508_15760# start pfet_03v3 ad=1.38p pd=4.76u as=0.65p ps=3.3u w=1u l=0.28u
X332 start start a_34108_37600# start pfet_03v3 ad=1.38p pd=4.76u as=0.65p ps=3.3u w=1u l=0.28u
X333 start a_3428_20424# a_3308_20560# start pfet_03v3 ad=1.38p pd=4.76u as=0.65p ps=3.3u w=1u l=0.28u
X334 start a_18508_46000# a_19708_46000# start pfet_03v3 ad=1.38p pd=4.76u as=0.65p ps=3.3u w=1u l=0.28u
X335 start start start start pfet_03v3 ad=0.65p pd=3.3u as=0 ps=0 w=1u l=0.28u
X336 start a_2228_15624# a_2108_15760# start nfet_03v3 ad=0.66p pd=3.64u as=0.305p ps=2.22u w=0.5u l=0.28u
X337 start a_53828_3864# a_52628_3864# start nfet_03v3 ad=0.66p pd=3.64u as=0.305p ps=2.22u w=0.5u l=0.28u
X338 start a_53708_12400# a_54908_12400# start pfet_03v3 ad=1.38p pd=4.76u as=0.65p ps=3.3u w=1u l=0.28u
X339 start a_52628_3864# a_51428_3864# start pfet_03v3 ad=1.38p pd=4.76u as=0.65p ps=3.3u w=1u l=0.28u
X340 start a_38108_54400# dac_in[5] start pfet_03v3 ad=1.38p pd=4.76u as=0.65p ps=3.3u w=1u l=0.28u
X341 start start a_51708_54400# start pfet_03v3 ad=1.104p pd=4.36u as=0.52p ps=2.9u w=0.8u l=0.28u
X342 start comp_out_p comp_out_p start pfet_03v3 ad=1.38p pd=4.76u as=0.65p ps=3.3u w=1u l=0.28u
X343 start comp_done a_42908_19200# start pfet_03v3 ad=1.38p pd=4.76u as=0.65p ps=3.3u w=1u l=0.28u
X344 start a_57428_9464# a_56228_9464# start pfet_03v3 ad=1.38p pd=4.76u as=0.65p ps=3.3u w=1u l=0.28u
X345 start comp_out_p a_4108_41600# start pfet_03v3 ad=1.38p pd=4.76u as=0.65p ps=3.3u w=1u l=0.28u
X346 start a_50908_33600# dout[5] start nfet_03v3 ad=0.577p pd=3.52u as=0.2646p ps=2.1u w=0.42u l=0.28u
X347 start start a_34108_41600# start nfet_03v3 ad=0.66p pd=3.64u as=0.305p ps=2.22u w=0.5u l=0.28u
X348 start a_57308_12400# a_58508_12400# start nfet_03v3 ad=0.66p pd=3.64u as=0.305p ps=2.22u w=0.5u l=0.28u
X349 a_39494_49200# a_36908_50400# a_37028_54264# start nfet_03v3 ad=0.305p pd=2.22u as=0.305p ps=2.22u w=0.5u l=0.28u
X350 start a_23428_54264# a_23428_54264# start nfet_03v3 ad=0.577p pd=3.52u as=0.2646p ps=2.1u w=0.42u l=0.28u
X351 start a_24508_1360# a_26908_1360# start nfet_03v3 ad=0.66p pd=3.64u as=0.305p ps=2.22u w=0.5u l=0.28u
X352 start a_33428_3864# a_33308_4000# start nfet_03v3 ad=0.66p pd=3.64u as=0.305p ps=2.22u w=0.5u l=0.28u
X353 start a_4108_41600# a_7708_41600# start nfet_03v3 ad=0.66p pd=3.64u as=0.305p ps=2.22u w=0.5u l=0.28u
X354 start a_10108_29600# a_12508_29600# start pfet_03v3 ad=1.38p pd=4.76u as=0.65p ps=3.3u w=1u l=0.28u
X355 start a_59708_1200# a_60908_1200# start pfet_03v3 ad=1.38p pd=4.76u as=0.65p ps=3.3u w=1u l=0.28u
X356 start dout[5] a_42508_33600# start pfet_03v3 ad=1.104p pd=4.36u as=0.52p ps=2.9u w=0.8u l=0.28u
X357 start a_3428_15624# a_3308_15760# start pfet_03v3 ad=1.38p pd=4.76u as=0.65p ps=3.3u w=1u l=0.28u
X358 start a_53828_9464# a_52628_9464# start nfet_03v3 ad=0.66p pd=3.64u as=0.305p ps=2.22u w=0.5u l=0.28u
X359 start a_37028_9464# a_35828_9464# start pfet_03v3 ad=1.38p pd=4.76u as=0.65p ps=3.3u w=1u l=0.28u
X360 start a_46508_12400# a_47708_12400# start pfet_03v3 ad=1.38p pd=4.76u as=0.65p ps=3.3u w=1u l=0.28u
X361 a_51094_28400# a_48508_29600# a_50908_29600# start nfet_03v3 ad=0.305p pd=2.22u as=0.305p ps=2.22u w=0.5u l=0.28u
X362 start start start start pfet_03v3 ad=0.52p pd=2.9u as=0 ps=0 w=0.8u l=0.28u
X363 start a_44908_54400# dac_in[6] start pfet_03v3 ad=1.38p pd=4.76u as=0.65p ps=3.3u w=1u l=0.28u
X364 a_3308_20560# a_2228_20424# a_4508_20560# start nfet_03v3 ad=0.305p pd=2.22u as=0.305p ps=2.22u w=0.5u l=0.28u
X365 start a_52628_15064# a_51428_15064# start pfet_03v3 ad=1.38p pd=4.76u as=0.65p ps=3.3u w=1u l=0.28u
X366 start a_58628_3864# a_57428_3864# start nfet_03v3 ad=0.66p pd=3.64u as=0.305p ps=2.22u w=0.5u l=0.28u
X367 start start a_17308_1360# start nfet_03v3 ad=0.66p pd=3.64u as=0.305p ps=2.22u w=0.5u l=0.28u
X368 start a_37028_54264# a_37028_54264# start nfet_03v3 ad=0.577p pd=3.52u as=0.2646p ps=2.1u w=0.42u l=0.28u
X369 start a_57428_3864# a_56228_3864# start pfet_03v3 ad=1.38p pd=4.76u as=0.65p ps=3.3u w=1u l=0.28u
X370 start a_58508_1200# a_59708_1200# start nfet_03v3 ad=0.66p pd=3.64u as=0.305p ps=2.22u w=0.5u l=0.28u
X371 start comp_out_p a_4294_36400# start nfet_03v3 ad=0.66p pd=3.64u as=0.305p ps=2.22u w=0.5u l=0.28u
X372 a_12694_32400# a_10108_33600# a_12508_33600# start nfet_03v3 ad=0.305p pd=2.22u as=0.305p ps=2.22u w=0.5u l=0.28u
X373 start a_9828_54264# a_9708_54400# start pfet_03v3 ad=1.104p pd=4.36u as=0.52p ps=2.9u w=0.8u l=0.28u
X374 start a_50108_6800# a_51308_6800# start pfet_03v3 ad=1.38p pd=4.76u as=0.65p ps=3.3u w=1u l=0.28u
X375 start a_33428_9464# a_33308_9600# start nfet_03v3 ad=0.66p pd=3.64u as=0.305p ps=2.22u w=0.5u l=0.28u
X376 start a_18508_37600# a_19708_37600# start pfet_03v3 ad=1.38p pd=4.76u as=0.65p ps=3.3u w=1u l=0.28u
X377 start dout[0] a_2908_50400# start pfet_03v3 ad=1.104p pd=4.36u as=0.52p ps=2.9u w=0.8u l=0.28u
X378 start a_48508_41600# a_50908_41600# start pfet_03v3 ad=1.38p pd=4.76u as=0.65p ps=3.3u w=1u l=0.28u
X379 start a_33308_24800# a_35894_23600# start nfet_03v3 ad=0.66p pd=3.64u as=0.305p ps=2.22u w=0.5u l=0.28u
X380 start a_38228_3864# a_37028_3864# start nfet_03v3 ad=0.66p pd=3.64u as=0.305p ps=2.22u w=0.5u l=0.28u
X381 a_43894_28400# a_41308_29600# a_43708_29600# start nfet_03v3 ad=0.305p pd=2.22u as=0.305p ps=2.22u w=0.5u l=0.28u
X382 start a_37028_3864# a_35828_3864# start pfet_03v3 ad=1.38p pd=4.76u as=0.65p ps=3.3u w=1u l=0.28u
X383 start a_17308_6160# a_18508_6160# start nfet_03v3 ad=0.66p pd=3.64u as=0.305p ps=2.22u w=0.5u l=0.28u
X384 start a_4108_46000# a_5308_46000# start nfet_03v3 ad=0.66p pd=3.64u as=0.305p ps=2.22u w=0.5u l=0.28u
X385 start a_2908_29600# a_10108_29600# start nfet_03v3 ad=0.577p pd=3.52u as=0.2646p ps=2.1u w=0.42u l=0.28u
X386 start a_10628_6024# a_9308_6160# start pfet_03v3 ad=1.38p pd=4.76u as=0.65p ps=3.3u w=1u l=0.28u
X387 start a_58628_9464# a_57428_9464# start nfet_03v3 ad=0.66p pd=3.64u as=0.305p ps=2.22u w=0.5u l=0.28u
X388 start start a_17708_54400# start pfet_03v3 ad=1.104p pd=4.36u as=0.52p ps=2.9u w=0.8u l=0.28u
X389 start a_47828_9464# a_46628_9464# start pfet_03v3 ad=1.38p pd=4.76u as=0.65p ps=3.3u w=1u l=0.28u
X390 start a_18508_10960# a_17308_10960# start pfet_03v3 ad=0.6034p pd=3.64u as=0.2822p ps=2.18u w=0.42u l=2u
X391 start a_18508_41600# a_19894_40400# start nfet_03v3 ad=0.66p pd=3.64u as=0.305p ps=2.22u w=0.5u l=0.28u
X392 start a_15028_6024# a_14908_6160# start pfet_03v3 ad=1.38p pd=4.76u as=0.65p ps=3.3u w=1u l=0.28u
X393 start a_44108_12400# a_45308_12400# start nfet_03v3 ad=0.66p pd=3.64u as=0.305p ps=2.22u w=0.5u l=0.28u
X394 start a_43828_54264# a_43828_54264# start nfet_03v3 ad=0.577p pd=3.52u as=0.2646p ps=2.1u w=0.42u l=0.28u
X395 start comp_out_p a_10908_50400# start pfet_03v3 ad=1.104p pd=4.36u as=0.52p ps=2.9u w=0.8u l=0.28u
X396 start start a_44908_54400# start nfet_03v3 ad=0.577p pd=3.52u as=0.2646p ps=2.1u w=0.42u l=0.28u
X397 start a_11308_37600# a_12508_37600# start pfet_03v3 ad=1.38p pd=4.76u as=0.65p ps=3.3u w=1u l=0.28u
X398 start comp_out_p comp_out_p start pfet_03v3 ad=1.38p pd=4.76u as=0.65p ps=3.3u w=1u l=0.28u
X399 a_5708_20560# a_2228_20424# a_8108_20560# start pfet_03v3 ad=0.65p pd=3.3u as=0.65p ps=3.3u w=1u l=0.28u
X400 start a_50228_15064# a_49028_15064# start nfet_03v3 ad=0.66p pd=3.64u as=0.305p ps=2.22u w=0.5u l=0.28u
X401 start a_41308_41600# a_43708_41600# start pfet_03v3 ad=1.38p pd=4.76u as=0.65p ps=3.3u w=1u l=0.28u
X402 a_16108_10960# a_15028_10824# a_17308_10960# start nfet_03v3 ad=0.305p pd=2.22u as=0.305p ps=2.22u w=0.5u l=0.28u
X403 start a_6508_46000# a_7708_46000# start pfet_03v3 ad=1.38p pd=4.76u as=0.65p ps=3.3u w=1u l=0.28u
X404 start a_50108_1200# a_51308_1200# start pfet_03v3 ad=1.38p pd=4.76u as=0.65p ps=3.3u w=1u l=0.28u
X405 start a_38228_9464# a_37028_9464# start nfet_03v3 ad=0.66p pd=3.64u as=0.305p ps=2.22u w=0.5u l=0.28u
X406 start a_33308_12400# a_34508_12400# start pfet_03v3 ad=1.38p pd=4.76u as=0.65p ps=3.3u w=1u l=0.28u
X407 start a_2908_41600# a_10108_41600# start pfet_03v3 ad=1.104p pd=4.36u as=0.52p ps=2.9u w=0.8u l=0.28u
X408 start a_5708_15760# a_4508_15760# start nfet_03v3 ad=0.577p pd=3.52u as=0.2646p ps=2.1u w=0.42u l=2.4u
X409 start a_54908_6800# a_56108_6800# start pfet_03v3 ad=1.38p pd=4.76u as=0.65p ps=3.3u w=1u l=0.28u
X410 start a_49708_37600# a_51094_36400# start nfet_03v3 ad=0.66p pd=3.64u as=0.305p ps=2.22u w=0.5u l=0.28u
X411 start a_17308_33600# a_19708_33600# start pfet_03v3 ad=1.38p pd=4.76u as=0.65p ps=3.3u w=1u l=0.28u
X412 start start start start nfet_03v3 ad=0.2646p pd=2.1u as=0 ps=0 w=0.42u l=2.4u
X413 start a_11308_41600# a_12694_40400# start nfet_03v3 ad=0.66p pd=3.64u as=0.305p ps=2.22u w=0.5u l=0.28u
X414 start a_35308_41600# a_38908_41600# start nfet_03v3 ad=0.66p pd=3.64u as=0.305p ps=2.22u w=0.5u l=0.28u
X415 start dac_in[0] dac_in[0] start pfet_03v3 ad=1.104p pd=4.36u as=0.52p ps=2.9u w=0.8u l=0.28u
X416 start a_34108_37600# a_41308_37600# start pfet_03v3 ad=1.104p pd=4.36u as=0.52p ps=2.9u w=0.8u l=0.28u
X417 start sample_en a_46628_3864# start pfet_03v3 ad=1.38p pd=4.76u as=0.65p ps=3.3u w=1u l=0.28u
X418 start a_15028_15624# a_14908_15760# start nfet_03v3 ad=0.66p pd=3.64u as=0.305p ps=2.22u w=0.5u l=0.28u
X419 start a_51308_6800# a_52508_6800# start nfet_03v3 ad=0.66p pd=3.64u as=0.305p ps=2.22u w=0.5u l=0.28u
X420 start comp_out_p a_17308_29600# start pfet_03v3 ad=1.104p pd=4.36u as=0.52p ps=2.9u w=0.8u l=0.28u
X421 start a_3428_6024# a_3308_6160# start nfet_03v3 ad=0.66p pd=3.64u as=0.305p ps=2.22u w=0.5u l=0.28u
X422 start a_22108_6160# a_20908_6160# start pfet_03v3 ad=0.6034p pd=3.64u as=0.2822p ps=2.18u w=0.42u l=2u
X423 start a_40508_6800# a_41708_6800# start pfet_03v3 ad=1.38p pd=4.76u as=0.65p ps=3.3u w=1u l=0.28u
X424 start a_10628_20424# a_9494_19200# start nfet_03v3 ad=0.66p pd=3.64u as=0.305p ps=2.22u w=0.5u l=0.28u
X425 a_5708_15760# a_2228_15624# a_8108_15760# start pfet_03v3 ad=0.65p pd=3.3u as=0.65p ps=3.3u w=1u l=0.28u
X426 start dout[2] a_11308_37600# start nfet_03v3 ad=0.577p pd=3.52u as=0.2646p ps=2.1u w=0.42u l=0.28u
X427 start a_54908_1200# a_56108_1200# start pfet_03v3 ad=1.38p pd=4.76u as=0.65p ps=3.3u w=1u l=0.28u
X428 start a_34108_41600# a_41308_41600# start nfet_03v3 ad=0.577p pd=3.52u as=0.2646p ps=2.1u w=0.42u l=0.28u
X429 a_9494_19200# a_8108_20560# a_9308_20560# start nfet_03v3 ad=0.305p pd=2.22u as=0.305p ps=2.22u w=0.5u l=0.28u
X430 start a_57428_15064# a_56228_15064# start pfet_03v3 ad=1.38p pd=4.76u as=0.65p ps=3.3u w=1u l=0.28u
X431 start a_17708_50400# a_16628_54264# start pfet_03v3 ad=1.38p pd=4.76u as=0.65p ps=3.3u w=1u l=0.28u
X432 start start start start pfet_03v3 ad=0.52p pd=2.9u as=0 ps=0 w=0.8u l=0.28u
X433 start a_61028_3864# a_59828_3864# start nfet_03v3 ad=0.66p pd=3.64u as=0.305p ps=2.22u w=0.5u l=0.28u
X434 start a_19708_46000# a_20908_46000# start pfet_03v3 ad=1.38p pd=4.76u as=0.65p ps=3.3u w=1u l=0.28u
X435 start comp_out_p a_17308_33600# start nfet_03v3 ad=0.577p pd=3.52u as=0.2646p ps=2.1u w=0.42u l=0.28u
X436 start a_2228_10824# a_2108_10960# start nfet_03v3 ad=0.66p pd=3.64u as=0.305p ps=2.22u w=0.5u l=0.28u
X437 start a_51708_54400# a_53094_53200# start nfet_03v3 ad=0.66p pd=3.64u as=0.305p ps=2.22u w=0.5u l=0.28u
X438 start a_42508_29600# a_43708_29600# start pfet_03v3 ad=1.38p pd=4.76u as=0.65p ps=3.3u w=1u l=0.28u
X439 start a_16228_15624# a_16108_15760# start pfet_03v3 ad=1.38p pd=4.76u as=0.65p ps=3.3u w=1u l=0.28u
X440 start a_10108_46000# a_11308_46000# start nfet_03v3 ad=0.66p pd=3.64u as=0.305p ps=2.22u w=0.5u l=0.28u
X441 a_5494_53200# a_2908_54400# dac_in[0] start nfet_03v3 ad=0.305p pd=2.22u as=0.305p ps=2.22u w=0.5u l=0.28u
X442 start a_47028_19064# done start pfet_03v3 ad=1.38p pd=4.76u as=0.65p ps=3.3u w=1u l=0.28u
X443 start a_40508_1200# a_41708_1200# start pfet_03v3 ad=1.38p pd=4.76u as=0.65p ps=3.3u w=1u l=0.28u
X444 start a_24508_1360# a_23308_1360# start nfet_03v3 ad=0.577p pd=3.52u as=0.2646p ps=2.1u w=0.42u l=2.4u
X445 start a_56108_6800# a_57308_6800# start nfet_03v3 ad=0.66p pd=3.64u as=0.305p ps=2.22u w=0.5u l=0.28u
X446 start a_35308_29600# a_48508_29600# start nfet_03v3 ad=0.577p pd=3.52u as=0.2646p ps=2.1u w=0.42u l=0.28u
X447 a_5708_6160# a_2108_6160# a_8108_6160# start nfet_03v3 ad=0.305p pd=2.22u as=0.305p ps=2.22u w=0.5u l=0.28u
X448 start a_45308_6800# a_46508_6800# start pfet_03v3 ad=1.38p pd=4.76u as=0.65p ps=3.3u w=1u l=0.28u
X449 start a_12508_29600# dout[0] start nfet_03v3 ad=0.577p pd=3.52u as=0.2646p ps=2.1u w=0.42u l=0.28u
X450 a_18508_6160# a_14908_6160# a_20908_6160# start nfet_03v3 ad=0.305p pd=2.22u as=0.305p ps=2.22u w=0.5u l=0.28u
X451 start a_42508_33600# a_43894_32400# start nfet_03v3 ad=0.66p pd=3.64u as=0.305p ps=2.22u w=0.5u l=0.28u
X452 start a_61028_9464# a_59828_9464# start nfet_03v3 ad=0.66p pd=3.64u as=0.305p ps=2.22u w=0.5u l=0.28u
X453 start a_50228_9464# a_49028_9464# start pfet_03v3 ad=1.38p pd=4.76u as=0.65p ps=3.3u w=1u l=0.28u
X454 start a_24508_50400# a_23428_54264# start pfet_03v3 ad=1.38p pd=4.76u as=0.65p ps=3.3u w=1u l=0.28u
X455 start a_35308_29600# a_38108_50400# start pfet_03v3 ad=1.104p pd=4.36u as=0.52p ps=2.9u w=0.8u l=0.28u
X456 start a_12508_46000# a_13708_46000# start pfet_03v3 ad=1.38p pd=4.76u as=0.65p ps=3.3u w=1u l=0.28u
X457 start a_9308_15760# a_8108_15760# start nfet_03v3 ad=0.577p pd=3.52u as=0.2646p ps=2.1u w=0.42u l=2.4u
X458 start a_18628_1224# a_18508_1360# start nfet_03v3 ad=0.66p pd=3.64u as=0.305p ps=2.22u w=0.5u l=0.28u
X459 start start a_24508_54400# start nfet_03v3 ad=0.577p pd=3.52u as=0.2646p ps=2.1u w=0.42u l=0.28u
X460 start a_10908_54400# a_12294_53200# start nfet_03v3 ad=0.66p pd=3.64u as=0.305p ps=2.22u w=0.5u l=0.28u
X461 start dout[0] a_2908_50400# start nfet_03v3 ad=0.577p pd=3.52u as=0.2646p ps=2.1u w=0.42u l=0.28u
X462 start dout[2] a_18508_37600# start pfet_03v3 ad=1.104p pd=4.36u as=0.52p ps=2.9u w=0.8u l=0.28u
X463 start a_55028_15064# a_53828_15064# start nfet_03v3 ad=0.66p pd=3.64u as=0.305p ps=2.22u w=0.5u l=0.28u
X464 start a_38908_41600# a_48508_41600# start pfet_03v3 ad=1.104p pd=4.36u as=0.52p ps=2.9u w=0.8u l=0.28u
X465 start start a_34108_33600# start pfet_03v3 ad=1.38p pd=4.76u as=0.65p ps=3.3u w=1u l=0.28u
X466 start a_35708_6800# a_36908_6800# start nfet_03v3 ad=0.66p pd=3.64u as=0.305p ps=2.22u w=0.5u l=0.28u
X467 start a_5708_10960# a_4508_10960# start nfet_03v3 ad=0.577p pd=3.52u as=0.2646p ps=2.1u w=0.42u l=2.4u
X468 start a_12508_41600# dout[3] start pfet_03v3 ad=1.104p pd=4.36u as=0.52p ps=2.9u w=0.8u l=0.28u
X469 start a_38108_12400# a_39308_12400# start pfet_03v3 ad=1.38p pd=4.76u as=0.65p ps=3.3u w=1u l=0.28u
X470 start comp_out_p comp_out_p start pfet_03v3 ad=1.38p pd=4.76u as=0.65p ps=3.3u w=1u l=0.28u
X471 start a_38108_50400# a_37028_54264# start pfet_03v3 ad=1.38p pd=4.76u as=0.65p ps=3.3u w=1u l=0.28u
X472 start comp_out_p a_51708_50400# start pfet_03v3 ad=1.104p pd=4.36u as=0.52p ps=2.9u w=0.8u l=0.28u
X473 start done a_33308_24800# start pfet_03v3 ad=1.38p pd=4.76u as=0.65p ps=3.3u w=1u l=0.28u
X474 start rst_latch rst_latch start pfet_03v3 ad=1.104p pd=4.36u as=0.52p ps=2.9u w=0.8u l=0.28u
X475 start a_44228_15064# a_44108_15200# start pfet_03v3 ad=1.38p pd=4.76u as=0.65p ps=3.3u w=1u l=0.28u
X476 start a_51308_12400# a_52508_12400# start nfet_03v3 ad=0.66p pd=3.64u as=0.305p ps=2.22u w=0.5u l=0.28u
X477 start comp_out_p a_10908_50400# start nfet_03v3 ad=0.577p pd=3.52u as=0.2646p ps=2.1u w=0.42u l=0.28u
X478 start dout[3] a_18508_41600# start nfet_03v3 ad=0.577p pd=3.52u as=0.2646p ps=2.1u w=0.42u l=0.28u
X479 start a_45308_1200# a_46508_1200# start pfet_03v3 ad=1.38p pd=4.76u as=0.65p ps=3.3u w=1u l=0.28u
X480 start a_43708_37600# dout[6] start pfet_03v3 ad=1.104p pd=4.36u as=0.52p ps=2.9u w=0.8u l=0.28u
X481 start start start start pfet_03v3 ad=0.65p pd=3.3u as=0 ps=0 w=1u l=0.28u
X482 start a_51428_3864# a_50228_3864# start nfet_03v3 ad=0.66p pd=3.64u as=0.305p ps=2.22u w=0.5u l=0.28u
X483 start a_50228_3864# a_49028_3864# start pfet_03v3 ad=1.38p pd=4.76u as=0.65p ps=3.3u w=1u l=0.28u
X484 start a_55028_9464# a_53828_9464# start pfet_03v3 ad=1.38p pd=4.76u as=0.65p ps=3.3u w=1u l=0.28u
X485 start a_40508_12400# a_41708_12400# start pfet_03v3 ad=1.38p pd=4.76u as=0.65p ps=3.3u w=1u l=0.28u
X486 start a_47828_15064# a_46628_15064# start nfet_03v3 ad=0.66p pd=3.64u as=0.305p ps=2.22u w=0.5u l=0.28u
X487 start start comp_out_p start pfet_03v3 ad=1.38p pd=4.76u as=0.65p ps=3.3u w=1u l=0.28u
X488 start a_30228_54264# start start pfet_03v3 ad=0.52p pd=2.9u as=0 ps=0 w=0.8u l=0.28u
X489 start dout[6] a_49708_37600# start nfet_03v3 ad=0.577p pd=3.52u as=0.2646p ps=2.1u w=0.42u l=0.28u
X490 a_35494_28400# comp_out_p a_35308_29600# start nfet_03v3 ad=0.305p pd=2.22u as=0.305p ps=2.22u w=0.5u l=0.28u
X491 a_18508_10960# a_15028_10824# a_20908_10960# start pfet_03v3 ad=0.65p pd=3.3u as=0.65p ps=3.3u w=1u l=0.28u
X492 start a_43708_41600# dout[7] start nfet_03v3 ad=0.577p pd=3.52u as=0.2646p ps=2.1u w=0.42u l=0.28u
X493 start a_46508_6800# a_47708_6800# start nfet_03v3 ad=0.66p pd=3.64u as=0.305p ps=2.22u w=0.5u l=0.28u
X494 start a_44908_50400# a_43828_54264# start pfet_03v3 ad=1.38p pd=4.76u as=0.65p ps=3.3u w=1u l=0.28u
X495 start a_35708_12400# a_36908_12400# start nfet_03v3 ad=0.66p pd=3.64u as=0.305p ps=2.22u w=0.5u l=0.28u
X496 start a_4508_10960# a_5708_10960# start pfet_03v3 ad=1.38p pd=4.76u as=0.65p ps=3.3u w=1u l=0.28u
X497 start a_51428_9464# a_50228_9464# start nfet_03v3 ad=0.66p pd=3.64u as=0.305p ps=2.22u w=0.5u l=0.28u
X498 a_22294_14400# a_20908_15760# a_22108_15760# start nfet_03v3 ad=0.305p pd=2.22u as=0.305p ps=2.22u w=0.5u l=0.28u
X499 start start a_32694_53200# start nfet_03v3 ad=0.66p pd=3.64u as=0.305p ps=2.22u w=0.5u l=0.28u
X500 a_10694_0# start start start nfet_03v3 ad=0.305p pd=2.22u as=0.305p ps=2.22u w=0.5u l=0.28u
X501 start a_40628_9464# a_39428_9464# start pfet_03v3 ad=1.38p pd=4.76u as=0.65p ps=3.3u w=1u l=0.28u
X502 start comp_out_p a_4294_32400# start nfet_03v3 ad=0.66p pd=3.64u as=0.305p ps=2.22u w=0.5u l=0.28u
X503 a_42294_23600# a_39708_24800# rst_latch start nfet_03v3 ad=0.305p pd=2.22u as=0.305p ps=2.22u w=0.5u l=0.28u
X504 start start start start nfet_03v3 ad=0.305p pd=2.22u as=0 ps=0 w=0.5u l=0.28u
X505 start dout[1] a_9708_50400# start pfet_03v3 ad=1.104p pd=4.36u as=0.52p ps=2.9u w=0.8u l=0.28u
X506 start comp_out_p a_35308_41600# start pfet_03v3 ad=1.38p pd=4.76u as=0.65p ps=3.3u w=1u l=0.28u
X507 start start start start pfet_03v3 ad=0.65p pd=3.3u as=0 ps=0 w=1u l=0.28u
X508 start a_58508_12400# a_59708_12400# start pfet_03v3 ad=1.38p pd=4.76u as=0.65p ps=3.3u w=1u l=0.28u
X509 start a_14908_46000# a_16108_46000# start nfet_03v3 ad=0.66p pd=3.64u as=0.305p ps=2.22u w=0.5u l=0.28u
X510 start a_18508_33600# a_19708_33600# start pfet_03v3 ad=1.38p pd=4.76u as=0.65p ps=3.3u w=1u l=0.28u
X511 start a_56228_3864# a_55028_3864# start nfet_03v3 ad=0.66p pd=3.64u as=0.305p ps=2.22u w=0.5u l=0.28u
X512 start a_55028_3864# a_53828_3864# start pfet_03v3 ad=1.38p pd=4.76u as=0.65p ps=3.3u w=1u l=0.28u
X513 start a_37028_54264# a_36908_54400# start pfet_03v3 ad=1.104p pd=4.36u as=0.52p ps=2.9u w=0.8u l=0.28u
X514 start start start start nfet_03v3 ad=0.2646p pd=2.1u as=0 ps=0 w=0.42u l=0.28u
X515 start a_17708_50400# a_19094_49200# start nfet_03v3 ad=0.66p pd=3.64u as=0.305p ps=2.22u w=0.5u l=0.28u
X516 start start a_2908_29600# start nfet_03v3 ad=0.66p pd=3.64u as=0.305p ps=2.22u w=0.5u l=0.28u
X517 start comp_out_p a_17708_50400# start pfet_03v3 ad=1.104p pd=4.36u as=0.52p ps=2.9u w=0.8u l=0.28u
X518 start a_49708_29600# a_50908_29600# start pfet_03v3 ad=1.38p pd=4.76u as=0.65p ps=3.3u w=1u l=0.28u
X519 start a_23428_15624# a_22108_15760# start pfet_03v3 ad=1.38p pd=4.76u as=0.65p ps=3.3u w=1u l=0.28u
X520 start a_17308_46000# a_18508_46000# start pfet_03v3 ad=1.38p pd=4.76u as=0.65p ps=3.3u w=1u l=0.28u
X521 start a_2228_20424# a_2108_20560# start pfet_03v3 ad=1.38p pd=4.76u as=0.65p ps=3.3u w=1u l=0.28u
X522 start a_9308_6160# a_11708_6160# start nfet_03v3 ad=0.66p pd=3.64u as=0.305p ps=2.22u w=0.5u l=0.28u
X523 start a_41828_3864# a_40628_3864# start nfet_03v3 ad=0.66p pd=3.64u as=0.305p ps=2.22u w=0.5u l=0.28u
X524 start a_16228_6024# a_16108_6160# start nfet_03v3 ad=0.66p pd=3.64u as=0.305p ps=2.22u w=0.5u l=0.28u
X525 start a_11308_33600# a_12508_33600# start pfet_03v3 ad=1.38p pd=4.76u as=0.65p ps=3.3u w=1u l=0.28u
X526 start comp_out_p comp_out_p start pfet_03v3 ad=1.38p pd=4.76u as=0.65p ps=3.3u w=1u l=0.28u
X527 start a_40628_3864# a_39428_3864# start pfet_03v3 ad=1.38p pd=4.76u as=0.65p ps=3.3u w=1u l=0.28u
X528 start a_56228_9464# a_55028_9464# start nfet_03v3 ad=0.66p pd=3.64u as=0.305p ps=2.22u w=0.5u l=0.28u
X529 start a_50628_54264# a_50508_54400# start pfet_03v3 ad=1.104p pd=4.36u as=0.52p ps=2.9u w=0.8u l=0.28u
X530 start start a_42908_19200# start pfet_03v3 ad=1.38p pd=4.76u as=0.65p ps=3.3u w=1u l=0.28u
X531 start a_45428_9464# a_44228_9464# start pfet_03v3 ad=1.38p pd=4.76u as=0.65p ps=3.3u w=1u l=0.28u
X532 start comp_out_p a_35494_36400# start nfet_03v3 ad=0.66p pd=3.64u as=0.305p ps=2.22u w=0.5u l=0.28u
X533 start a_19708_29600# dout[0] start nfet_03v3 ad=0.577p pd=3.52u as=0.2646p ps=2.1u w=0.42u l=0.28u
X534 start a_4508_6160# a_5708_6160# start pfet_03v3 ad=1.38p pd=4.76u as=0.65p ps=3.3u w=1u l=0.28u
X535 start start a_2908_41600# start pfet_03v3 ad=1.38p pd=4.76u as=0.65p ps=3.3u w=1u l=0.28u
X536 start a_49708_33600# a_51094_32400# start nfet_03v3 ad=0.66p pd=3.64u as=0.305p ps=2.22u w=0.5u l=0.28u
X537 start a_49028_15064# a_47828_15064# start pfet_03v3 ad=1.38p pd=4.76u as=0.65p ps=3.3u w=1u l=0.28u
X538 start a_10628_10824# a_9494_9600# start nfet_03v3 ad=0.66p pd=3.64u as=0.305p ps=2.22u w=0.5u l=0.28u
X539 start a_56108_12400# a_57308_12400# start nfet_03v3 ad=0.66p pd=3.64u as=0.305p ps=2.22u w=0.5u l=0.28u
X540 start a_24508_50400# a_25894_49200# start nfet_03v3 ad=0.66p pd=3.64u as=0.305p ps=2.22u w=0.5u l=0.28u
X541 start a_35308_29600# a_38108_50400# start nfet_03v3 ad=0.577p pd=3.52u as=0.2646p ps=2.1u w=0.42u l=0.28u
X542 start a_15028_10824# a_14908_10960# start nfet_03v3 ad=0.66p pd=3.64u as=0.305p ps=2.22u w=0.5u l=0.28u
X543 start dout[0] a_11308_29600# start pfet_03v3 ad=1.104p pd=4.36u as=0.52p ps=2.9u w=0.8u l=0.28u
X544 start a_3028_54264# a_3028_54264# start pfet_03v3 ad=1.104p pd=4.36u as=0.52p ps=2.9u w=0.8u l=0.28u
X545 start a_34108_33600# a_41308_33600# start pfet_03v3 ad=1.104p pd=4.36u as=0.52p ps=2.9u w=0.8u l=0.28u
X546 start a_2228_15624# a_2108_15760# start pfet_03v3 ad=1.38p pd=4.76u as=0.65p ps=3.3u w=1u l=0.28u
X547 start a_41828_9464# a_40628_9464# start nfet_03v3 ad=0.66p pd=3.64u as=0.305p ps=2.22u w=0.5u l=0.28u
X548 start a_19708_41600# dout[3] start pfet_03v3 ad=1.104p pd=4.36u as=0.52p ps=2.9u w=0.8u l=0.28u
X549 start a_23308_1360# a_24508_1360# start pfet_03v3 ad=1.38p pd=4.76u as=0.65p ps=3.3u w=1u l=0.28u
X550 start a_45308_12400# a_46508_12400# start pfet_03v3 ad=1.38p pd=4.76u as=0.65p ps=3.3u w=1u l=0.28u
X551 start start a_33308_24800# start pfet_03v3 ad=1.38p pd=4.76u as=0.65p ps=3.3u w=1u l=0.28u
X552 a_18508_1360# start a_19708_1360# start nfet_03v3 ad=0.305p pd=2.22u as=0.305p ps=2.22u w=0.5u l=0.28u
X553 start dac_in[4] dac_in[4] start pfet_03v3 ad=1.104p pd=4.36u as=0.52p ps=2.9u w=0.8u l=0.28u
X554 start a_43708_54400# dac_in[6] start pfet_03v3 ad=1.38p pd=4.76u as=0.65p ps=3.3u w=1u l=0.28u
X555 start a_3428_20424# a_3308_20560# start nfet_03v3 ad=0.66p pd=3.64u as=0.305p ps=2.22u w=0.5u l=0.28u
X556 start a_9308_10960# a_11708_10960# start pfet_03v3 ad=1.38p pd=4.76u as=0.65p ps=3.3u w=1u l=0.28u
X557 start comp_out_p a_51708_50400# start nfet_03v3 ad=0.577p pd=3.52u as=0.2646p ps=2.1u w=0.42u l=0.28u
X558 start a_51428_15064# a_50228_15064# start pfet_03v3 ad=1.38p pd=4.76u as=0.65p ps=3.3u w=1u l=0.28u
X559 start a_46628_3864# a_45428_3864# start nfet_03v3 ad=0.66p pd=3.64u as=0.305p ps=2.22u w=0.5u l=0.28u
X560 start a_38108_50400# a_39494_49200# start nfet_03v3 ad=0.66p pd=3.64u as=0.305p ps=2.22u w=0.5u l=0.28u
X561 start a_45428_3864# a_44228_3864# start pfet_03v3 ad=1.38p pd=4.76u as=0.65p ps=3.3u w=1u l=0.28u
X562 start a_9308_6160# a_8108_6160# start pfet_03v3 ad=0.6034p pd=3.64u as=0.2822p ps=2.18u w=0.42u l=2u
X563 a_4294_36400# comp_out_p comp_out_p start nfet_03v3 ad=0.305p pd=2.22u as=0.305p ps=2.22u w=0.5u l=0.28u
X564 start dout[1] a_11308_33600# start nfet_03v3 ad=0.577p pd=3.52u as=0.2646p ps=2.1u w=0.42u l=0.28u
X565 start a_50908_37600# dout[6] start pfet_03v3 ad=1.104p pd=4.36u as=0.52p ps=2.9u w=0.8u l=0.28u
X566 start a_48908_6800# a_50108_6800# start nfet_03v3 ad=0.66p pd=3.64u as=0.305p ps=2.22u w=0.5u l=0.28u
X567 start a_23428_6024# a_22108_6160# start pfet_03v3 ad=1.38p pd=4.76u as=0.65p ps=3.3u w=1u l=0.28u
X568 start dout[4] a_42508_29600# start nfet_03v3 ad=0.577p pd=3.52u as=0.2646p ps=2.1u w=0.42u l=0.28u
X569 start a_22108_10960# a_20908_10960# start nfet_03v3 ad=0.577p pd=3.52u as=0.2646p ps=2.1u w=0.42u l=2.4u
X570 start a_2908_46000# a_4108_46000# start nfet_03v3 ad=0.66p pd=3.64u as=0.305p ps=2.22u w=0.5u l=0.28u
X571 start a_46628_9464# a_45428_9464# start nfet_03v3 ad=0.66p pd=3.64u as=0.305p ps=2.22u w=0.5u l=0.28u
X572 start a_16628_54264# a_16508_54400# start pfet_03v3 ad=1.104p pd=4.36u as=0.52p ps=2.9u w=0.8u l=0.28u
X573 start a_50908_41600# dout[7] start nfet_03v3 ad=0.577p pd=3.52u as=0.2646p ps=2.1u w=0.42u l=0.28u
X574 start a_35828_9464# a_34628_9464# start pfet_03v3 ad=1.38p pd=4.76u as=0.65p ps=3.3u w=1u l=0.28u
X575 start a_17308_10960# a_18508_10960# start pfet_03v3 ad=1.38p pd=4.76u as=0.65p ps=3.3u w=1u l=0.28u
X576 start a_42908_12400# a_44108_12400# start nfet_03v3 ad=0.66p pd=3.64u as=0.305p ps=2.22u w=0.5u l=0.28u
X577 start a_44908_50400# a_46294_49200# start nfet_03v3 ad=0.66p pd=3.64u as=0.305p ps=2.22u w=0.5u l=0.28u
X578 start comp_done a_33308_19200# start nfet_03v3 ad=0.66p pd=3.64u as=0.305p ps=2.22u w=0.5u l=0.28u
X579 start a_48908_1200# a_50108_1200# start nfet_03v3 ad=0.66p pd=3.64u as=0.305p ps=2.22u w=0.5u l=0.28u
X580 start a_10108_37600# a_12508_37600# start pfet_03v3 ad=1.38p pd=4.76u as=0.65p ps=3.3u w=1u l=0.28u
X581 start a_5708_20560# a_4508_20560# start pfet_03v3 ad=0.6034p pd=3.64u as=0.2822p ps=2.18u w=0.42u l=2u
X582 start a_18508_15760# a_17308_15760# start nfet_03v3 ad=0.577p pd=3.52u as=0.2646p ps=2.1u w=0.42u l=2.4u
X583 start dout[1] a_9708_50400# start nfet_03v3 ad=0.577p pd=3.52u as=0.2646p ps=2.1u w=0.42u l=0.28u
X584 start dout[7] a_42508_41600# start pfet_03v3 ad=1.104p pd=4.36u as=0.52p ps=2.9u w=0.8u l=0.28u
X585 start a_5308_46000# a_6508_46000# start pfet_03v3 ad=1.38p pd=4.76u as=0.65p ps=3.3u w=1u l=0.28u
X586 start a_20908_46000# a_39708_24800# start nfet_03v3 ad=0.577p pd=3.52u as=0.2646p ps=2.1u w=0.42u l=0.28u
X587 start a_53708_6800# a_54908_6800# start nfet_03v3 ad=0.66p pd=3.64u as=0.305p ps=2.22u w=0.5u l=0.28u
X588 start a_33428_12264# a_33308_12400# start pfet_03v3 ad=1.38p pd=4.76u as=0.65p ps=3.3u w=1u l=0.28u
X589 a_51094_36400# a_48508_37600# a_50908_37600# start nfet_03v3 ad=0.305p pd=2.22u as=0.305p ps=2.22u w=0.5u l=0.28u
X590 start a_42908_6800# a_44108_6800# start pfet_03v3 ad=1.38p pd=4.76u as=0.65p ps=3.3u w=1u l=0.28u
X591 start dac_in[7] dac_in[7] start pfet_03v3 ad=1.104p pd=4.36u as=0.52p ps=2.9u w=0.8u l=0.28u
X592 start dout[1] a_18508_33600# start pfet_03v3 ad=1.104p pd=4.36u as=0.52p ps=2.9u w=0.8u l=0.28u
X593 start a_11828_1424# a_10694_0# start nfet_03v3 ad=0.66p pd=3.64u as=0.305p ps=2.22u w=0.5u l=0.28u
X594 start a_39308_1200# a_40508_1200# start nfet_03v3 ad=0.66p pd=3.64u as=0.305p ps=2.22u w=0.5u l=0.28u
X595 a_12694_40400# a_10108_41600# a_12508_41600# start nfet_03v3 ad=0.305p pd=2.22u as=0.305p ps=2.22u w=0.5u l=0.28u
X596 start a_4108_54400# dac_in[0] start pfet_03v3 ad=1.38p pd=4.76u as=0.65p ps=3.3u w=1u l=0.28u
X597 start comp_out_p a_17708_50400# start nfet_03v3 ad=0.577p pd=3.52u as=0.2646p ps=2.1u w=0.42u l=0.28u
X598 start a_35828_3864# a_34628_3864# start pfet_03v3 ad=1.38p pd=4.76u as=0.65p ps=3.3u w=1u l=0.28u
X599 start dout[4] a_49708_29600# start pfet_03v3 ad=1.104p pd=4.36u as=0.52p ps=2.9u w=0.8u l=0.28u
X600 start a_39308_6800# a_40508_6800# start nfet_03v3 ad=0.66p pd=3.64u as=0.305p ps=2.22u w=0.5u l=0.28u
X601 start a_59708_12400# a_60908_12400# start pfet_03v3 ad=1.38p pd=4.76u as=0.65p ps=3.3u w=1u l=0.28u
X602 start a_43708_33600# dout[5] start pfet_03v3 ad=1.104p pd=4.36u as=0.52p ps=2.9u w=0.8u l=0.28u
X603 start a_5708_15760# a_4508_15760# start pfet_03v3 ad=0.6034p pd=3.64u as=0.2822p ps=2.18u w=0.42u l=2u
X604 a_43894_36400# a_41308_37600# a_43708_37600# start nfet_03v3 ad=0.305p pd=2.22u as=0.305p ps=2.22u w=0.5u l=0.28u
X605 start a_2908_37600# a_10108_37600# start nfet_03v3 ad=0.577p pd=3.52u as=0.2646p ps=2.1u w=0.42u l=0.28u
X606 start dac_in[1] dac_in[1] start pfet_03v3 ad=1.104p pd=4.36u as=0.52p ps=2.9u w=0.8u l=0.28u
X607 start a_23308_54400# dac_in[3] start pfet_03v3 ad=1.38p pd=4.76u as=0.65p ps=3.3u w=1u l=0.28u
X608 a_19894_28400# a_17308_29600# a_19708_29600# start nfet_03v3 ad=0.305p pd=2.22u as=0.305p ps=2.22u w=0.5u l=0.28u
X609 a_5708_20560# a_2108_20560# a_8108_20560# start nfet_03v3 ad=0.305p pd=2.22u as=0.305p ps=2.22u w=0.5u l=0.28u
X610 start a_56228_15064# a_55028_15064# start pfet_03v3 ad=1.38p pd=4.76u as=0.65p ps=3.3u w=1u l=0.28u
X611 start a_42908_1200# a_44108_1200# start pfet_03v3 ad=1.38p pd=4.76u as=0.65p ps=3.3u w=1u l=0.28u
X612 start dout[4] start start pfet_03v3 ad=0.52p pd=2.9u as=0 ps=0 w=0.8u l=0.28u
X613 start a_47708_6800# a_48908_6800# start pfet_03v3 ad=1.38p pd=4.76u as=0.65p ps=3.3u w=1u l=0.28u
X614 start dout[5] a_49708_33600# start nfet_03v3 ad=0.577p pd=3.52u as=0.2646p ps=2.1u w=0.42u l=0.28u
X615 start a_3428_1424# start start pfet_03v3 ad=0.65p pd=3.3u as=0 ps=0 w=1u l=0.28u
X616 a_18508_1360# a_17308_1360# a_19708_1360# start pfet_03v3 ad=0.65p pd=3.3u as=0.65p ps=3.3u w=1u l=0.28u
X617 a_53094_53200# a_50508_54400# dac_in[7] start nfet_03v3 ad=0.305p pd=2.22u as=0.305p ps=2.22u w=0.5u l=0.28u
X618 start a_15028_15624# a_14908_15760# start pfet_03v3 ad=1.38p pd=4.76u as=0.65p ps=3.3u w=1u l=0.28u
X619 start a_3028_54264# a_3028_54264# start nfet_03v3 ad=0.577p pd=3.52u as=0.2646p ps=2.1u w=0.42u l=0.28u
X620 start a_52508_12400# a_53708_12400# start pfet_03v3 ad=1.38p pd=4.76u as=0.65p ps=3.3u w=1u l=0.28u
X621 start a_8908_46000# a_10108_46000# start nfet_03v3 ad=0.66p pd=3.64u as=0.305p ps=2.22u w=0.5u l=0.28u
X622 start a_59828_15064# a_58628_15064# start nfet_03v3 ad=0.66p pd=3.64u as=0.305p ps=2.22u w=0.5u l=0.28u
X623 start start a_4108_54400# start nfet_03v3 ad=0.577p pd=3.52u as=0.2646p ps=2.1u w=0.42u l=0.28u
X624 start a_17308_41600# a_19708_41600# start pfet_03v3 ad=1.38p pd=4.76u as=0.65p ps=3.3u w=1u l=0.28u
X625 start a_44108_6800# a_45308_6800# start nfet_03v3 ad=0.66p pd=3.64u as=0.305p ps=2.22u w=0.5u l=0.28u
X626 start a_7708_46000# a_8908_46000# start nfet_03v3 ad=0.66p pd=3.64u as=0.305p ps=2.22u w=0.5u l=0.28u
X627 start a_17308_6160# a_18508_6160# start pfet_03v3 ad=1.38p pd=4.76u as=0.65p ps=3.3u w=1u l=0.28u
X628 start a_33308_6800# a_34508_6800# start pfet_03v3 ad=1.38p pd=4.76u as=0.65p ps=3.3u w=1u l=0.28u
X629 start a_9308_20560# a_8108_20560# start pfet_03v3 ad=0.6034p pd=3.64u as=0.2822p ps=2.18u w=0.42u l=2u
X630 start dout[5] a_36908_50400# start pfet_03v3 ad=1.104p pd=4.36u as=0.52p ps=2.9u w=0.8u l=0.28u
X631 start a_47708_12400# a_48908_12400# start nfet_03v3 ad=0.66p pd=3.64u as=0.305p ps=2.22u w=0.5u l=0.28u
X632 start a_11308_46000# a_12508_46000# start pfet_03v3 ad=1.38p pd=4.76u as=0.65p ps=3.3u w=1u l=0.28u
X633 start start a_35308_29600# start pfet_03v3 ad=1.38p pd=4.76u as=0.65p ps=3.3u w=1u l=0.28u
X634 start a_33308_24800# sample_en start nfet_03v3 ad=0.66p pd=3.64u as=0.305p ps=2.22u w=0.5u l=0.28u
X635 start a_47708_1200# a_48908_1200# start pfet_03v3 ad=1.38p pd=4.76u as=0.65p ps=3.3u w=1u l=0.28u
X636 a_12294_53200# a_9708_54400# dac_in[1] start nfet_03v3 ad=0.305p pd=2.22u as=0.305p ps=2.22u w=0.5u l=0.28u
X637 start a_23428_54264# a_23308_54400# start nfet_03v3 ad=0.577p pd=3.52u as=0.2646p ps=2.1u w=0.42u l=0.28u
X638 start comp_out_p a_17308_37600# start pfet_03v3 ad=1.104p pd=4.36u as=0.52p ps=2.9u w=0.8u l=0.28u
X639 start start start start pfet_03v3 ad=0.2822p pd=2.18u as=0 ps=0 w=0.42u l=2u
X640 start start start start nfet_03v3 ad=0.305p pd=2.22u as=0 ps=0 w=0.5u l=0.28u
X641 start a_58508_6800# a_59708_6800# start pfet_03v3 ad=1.38p pd=4.76u as=0.65p ps=3.3u w=1u l=0.28u
X642 start a_36908_12400# a_38108_12400# start pfet_03v3 ad=1.38p pd=4.76u as=0.65p ps=3.3u w=1u l=0.28u
X643 start a_40908_24800# rst_latch start pfet_03v3 ad=1.38p pd=4.76u as=0.65p ps=3.3u w=1u l=0.28u
X644 start a_22108_10960# a_20908_10960# start pfet_03v3 ad=0.6034p pd=3.64u as=0.2822p ps=2.18u w=0.42u l=2u
X645 start a_50108_12400# a_51308_12400# start nfet_03v3 ad=0.66p pd=3.64u as=0.305p ps=2.22u w=0.5u l=0.28u
X646 start dout[7] a_50508_50400# start pfet_03v3 ad=1.104p pd=4.36u as=0.52p ps=2.9u w=0.8u l=0.28u
X647 start a_35308_29600# a_35494_32400# start nfet_03v3 ad=0.66p pd=3.64u as=0.305p ps=2.22u w=0.5u l=0.28u
X648 start a_7708_41600# a_17308_41600# start nfet_03v3 ad=0.577p pd=3.52u as=0.2646p ps=2.1u w=0.42u l=0.28u
X649 start start start start nfet_03v3 ad=0.305p pd=2.22u as=0 ps=0 w=0.5u l=0.28u
X650 start a_33308_1200# a_34508_1200# start pfet_03v3 ad=1.38p pd=4.76u as=0.65p ps=3.3u w=1u l=0.28u
X651 start a_59708_1200# a_60908_1200# start nfet_03v3 ad=0.66p pd=3.64u as=0.305p ps=2.22u w=0.5u l=0.28u
X652 start a_42508_37600# a_43708_37600# start pfet_03v3 ad=1.38p pd=4.76u as=0.65p ps=3.3u w=1u l=0.28u
X653 start a_9308_15760# a_8108_15760# start pfet_03v3 ad=0.6034p pd=3.64u as=0.2822p ps=2.18u w=0.42u l=2u
X654 start a_38108_6800# a_39308_6800# start pfet_03v3 ad=1.38p pd=4.76u as=0.65p ps=3.3u w=1u l=0.28u
X655 a_19094_53200# a_16508_54400# dac_in[2] start nfet_03v3 ad=0.305p pd=2.22u as=0.305p ps=2.22u w=0.5u l=0.28u
X656 a_35894_23600# sample_en a_35708_24800# start nfet_03v3 ad=0.305p pd=2.22u as=0.305p ps=2.22u w=0.5u l=0.28u
X657 start a_43028_9464# a_41828_9464# start pfet_03v3 ad=1.38p pd=4.76u as=0.65p ps=3.3u w=1u l=0.28u
X658 start a_39308_12400# a_40508_12400# start pfet_03v3 ad=1.38p pd=4.76u as=0.65p ps=3.3u w=1u l=0.28u
X659 start a_46628_15064# a_45428_15064# start nfet_03v3 ad=0.66p pd=3.64u as=0.305p ps=2.22u w=0.5u l=0.28u
X660 start a_3428_6024# a_3308_6160# start pfet_03v3 ad=1.38p pd=4.76u as=0.65p ps=3.3u w=1u l=0.28u
X661 start comp_out_p comp_out_p start pfet_03v3 ad=1.38p pd=4.76u as=0.65p ps=3.3u w=1u l=0.28u
X662 start comp_out_p a_48508_37600# start nfet_03v3 ad=0.577p pd=3.52u as=0.2646p ps=2.1u w=0.42u l=0.28u
X663 start a_58508_1200# a_59708_1200# start pfet_03v3 ad=1.38p pd=4.76u as=0.65p ps=3.3u w=1u l=0.28u
X664 start a_50108_1200# a_51308_1200# start nfet_03v3 ad=0.66p pd=3.64u as=0.305p ps=2.22u w=0.5u l=0.28u
X665 start start a_34108_29600# start nfet_03v3 ad=0.66p pd=3.64u as=0.305p ps=2.22u w=0.5u l=0.28u
X666 start a_12508_37600# dout[2] start nfet_03v3 ad=0.577p pd=3.52u as=0.2646p ps=2.1u w=0.42u l=0.28u
X667 start a_34508_6800# a_35708_6800# start nfet_03v3 ad=0.66p pd=3.64u as=0.305p ps=2.22u w=0.5u l=0.28u
X668 start a_42508_41600# a_43894_40400# start nfet_03v3 ad=0.66p pd=3.64u as=0.305p ps=2.22u w=0.5u l=0.28u
X669 start a_4508_10960# a_5708_10960# start nfet_03v3 ad=0.66p pd=3.64u as=0.305p ps=2.22u w=0.5u l=0.28u
X670 start a_30228_54264# a_30228_54264# start pfet_03v3 ad=1.104p pd=4.36u as=0.52p ps=2.9u w=0.8u l=0.28u
X671 start a_43708_50400# a_43828_54264# start pfet_03v3 ad=1.38p pd=4.76u as=0.65p ps=3.3u w=1u l=0.28u
X672 start comp_out_p comp_out_p start nfet_03v3 ad=0.66p pd=3.64u as=0.305p ps=2.22u w=0.5u l=0.28u
X673 a_3308_10960# a_2108_10960# a_4508_10960# start pfet_03v3 ad=0.65p pd=3.3u as=0.65p ps=3.3u w=1u l=0.28u
X674 a_32694_53200# start dac_in[4] start nfet_03v3 ad=0.305p pd=2.22u as=0.305p ps=2.22u w=0.5u l=0.28u
X675 start a_43828_54264# a_43708_54400# start nfet_03v3 ad=0.577p pd=3.52u as=0.2646p ps=2.1u w=0.42u l=0.28u
X676 a_18508_15760# a_14908_15760# a_20908_15760# start nfet_03v3 ad=0.305p pd=2.22u as=0.305p ps=2.22u w=0.5u l=0.28u
X677 start dac_in[2] dac_in[2] start nfet_03v3 ad=0.577p pd=3.52u as=0.2646p ps=2.1u w=0.42u l=0.28u
X678 a_4294_32400# comp_out_p comp_out_p start nfet_03v3 ad=0.305p pd=2.22u as=0.305p ps=2.22u w=0.5u l=0.28u
X679 start start a_40908_24800# start nfet_03v3 ad=0.577p pd=3.52u as=0.2646p ps=2.1u w=0.42u l=0.28u
X680 start a_20908_1360# a_19708_1360# start pfet_03v3 ad=0.6034p pd=3.64u as=0.2822p ps=2.18u w=0.42u l=2u
X681 start a_40508_1200# a_41708_1200# start nfet_03v3 ad=0.66p pd=3.64u as=0.305p ps=2.22u w=0.5u l=0.28u
X682 start a_50908_33600# dout[5] start pfet_03v3 ad=1.104p pd=4.36u as=0.52p ps=2.9u w=0.8u l=0.28u
X683 start a_13708_46000# a_14908_46000# start nfet_03v3 ad=0.66p pd=3.64u as=0.305p ps=2.22u w=0.5u l=0.28u
X684 start start a_34108_41600# start pfet_03v3 ad=1.38p pd=4.76u as=0.65p ps=3.3u w=1u l=0.28u
X685 start a_4508_15760# a_5708_15760# start nfet_03v3 ad=0.66p pd=3.64u as=0.305p ps=2.22u w=0.5u l=0.28u
X686 start a_38108_1200# a_39308_1200# start pfet_03v3 ad=1.38p pd=4.76u as=0.65p ps=3.3u w=1u l=0.28u
X687 start a_57308_12400# a_58508_12400# start pfet_03v3 ad=1.38p pd=4.76u as=0.65p ps=3.3u w=1u l=0.28u
X688 start a_44228_3864# a_43028_3864# start nfet_03v3 ad=0.66p pd=3.64u as=0.305p ps=2.22u w=0.5u l=0.28u
X689 start a_43028_3864# a_41828_3864# start pfet_03v3 ad=1.38p pd=4.76u as=0.65p ps=3.3u w=1u l=0.28u
X690 start a_22108_6160# a_24508_6160# start nfet_03v3 ad=0.66p pd=3.64u as=0.305p ps=2.22u w=0.5u l=0.28u
X691 start a_4108_41600# a_7708_41600# start pfet_03v3 ad=1.38p pd=4.76u as=0.65p ps=3.3u w=1u l=0.28u
X692 a_5708_6160# a_2228_6024# a_8108_6160# start pfet_03v3 ad=0.65p pd=3.3u as=0.65p ps=3.3u w=1u l=0.28u
X693 start a_53828_9464# a_52628_9464# start pfet_03v3 ad=1.38p pd=4.76u as=0.65p ps=3.3u w=1u l=0.28u
X694 start dout[4] start start nfet_03v3 ad=0.2646p pd=2.1u as=0 ps=0 w=0.42u l=0.28u
X695 a_18508_6160# a_15028_6024# a_20908_6160# start pfet_03v3 ad=0.65p pd=3.3u as=0.65p ps=3.3u w=1u l=0.28u
X696 start a_20908_15760# a_22108_15760# start pfet_03v3 ad=1.38p pd=4.76u as=0.65p ps=3.3u w=1u l=0.28u
X697 start dout[2] a_16508_50400# start pfet_03v3 ad=1.104p pd=4.36u as=0.52p ps=2.9u w=0.8u l=0.28u
X698 start a_48508_29600# a_50908_29600# start pfet_03v3 ad=1.38p pd=4.76u as=0.65p ps=3.3u w=1u l=0.28u
X699 start a_9308_10960# a_8108_10960# start nfet_03v3 ad=0.577p pd=3.52u as=0.2646p ps=2.1u w=0.42u l=2.4u
X700 start a_16108_46000# a_17308_46000# start pfet_03v3 ad=1.38p pd=4.76u as=0.65p ps=3.3u w=1u l=0.28u
X701 a_39494_53200# a_36908_54400# dac_in[5] start nfet_03v3 ad=0.305p pd=2.22u as=0.305p ps=2.22u w=0.5u l=0.28u
X702 start dac_in[3] dac_in[3] start nfet_03v3 ad=0.577p pd=3.52u as=0.2646p ps=2.1u w=0.42u l=0.28u
X703 start a_23428_10824# a_22294_9600# start nfet_03v3 ad=0.66p pd=3.64u as=0.305p ps=2.22u w=0.5u l=0.28u
X704 start a_44228_9464# a_43028_9464# start nfet_03v3 ad=0.66p pd=3.64u as=0.305p ps=2.22u w=0.5u l=0.28u
X705 start comp_out_p comp_out_p start pfet_03v3 ad=1.38p pd=4.76u as=0.65p ps=3.3u w=1u l=0.28u
X706 start a_10108_33600# a_12508_33600# start pfet_03v3 ad=1.38p pd=4.76u as=0.65p ps=3.3u w=1u l=0.28u
X707 start a_24508_1360# a_26908_1360# start pfet_03v3 ad=1.38p pd=4.76u as=0.65p ps=3.3u w=1u l=0.28u
X708 start a_33428_9464# a_33308_9600# start pfet_03v3 ad=1.38p pd=4.76u as=0.65p ps=3.3u w=1u l=0.28u
X709 a_35494_36400# comp_out_p comp_out_p start nfet_03v3 ad=0.305p pd=2.22u as=0.305p ps=2.22u w=0.5u l=0.28u
X710 start a_18508_29600# a_19894_28400# start nfet_03v3 ad=0.66p pd=3.64u as=0.305p ps=2.22u w=0.5u l=0.28u
X711 a_51094_32400# a_48508_33600# a_50908_33600# start nfet_03v3 ad=0.305p pd=2.22u as=0.305p ps=2.22u w=0.5u l=0.28u
X712 start a_50628_54264# a_50628_54264# start pfet_03v3 ad=1.104p pd=4.36u as=0.52p ps=2.9u w=0.8u l=0.28u
X713 start a_33308_24800# a_35708_24800# start pfet_03v3 ad=1.38p pd=4.76u as=0.65p ps=3.3u w=1u l=0.28u
X714 start a_11828_1424# start start pfet_03v3 ad=0.65p pd=3.3u as=0 ps=0 w=1u l=0.28u
X715 start a_54908_12400# a_56108_12400# start nfet_03v3 ad=0.66p pd=3.64u as=0.305p ps=2.22u w=0.5u l=0.28u
X716 start a_49028_3864# sample_en start nfet_03v3 ad=0.66p pd=3.64u as=0.305p ps=2.22u w=0.5u l=0.28u
X717 start dout[5] a_36908_50400# start nfet_03v3 ad=0.577p pd=3.52u as=0.2646p ps=2.1u w=0.42u l=0.28u
X718 start dac_in[5] dac_in[5] start nfet_03v3 ad=0.577p pd=3.52u as=0.2646p ps=2.1u w=0.42u l=0.28u
X719 start a_41308_29600# a_43708_29600# start pfet_03v3 ad=1.38p pd=4.76u as=0.65p ps=3.3u w=1u l=0.28u
X720 start a_53828_3864# a_52628_3864# start pfet_03v3 ad=1.38p pd=4.76u as=0.65p ps=3.3u w=1u l=0.28u
X721 start a_2908_29600# a_10108_29600# start pfet_03v3 ad=1.104p pd=4.36u as=0.52p ps=2.9u w=0.8u l=0.28u
X722 start a_58628_9464# a_57428_9464# start pfet_03v3 ad=1.38p pd=4.76u as=0.65p ps=3.3u w=1u l=0.28u
X723 start a_61028_15064# a_59828_15064# start nfet_03v3 ad=0.66p pd=3.64u as=0.305p ps=2.22u w=0.5u l=0.28u
X724 start a_4108_50400# a_3028_54264# start pfet_03v3 ad=1.38p pd=4.76u as=0.65p ps=3.3u w=1u l=0.28u
X725 start comp_out_p a_4294_40400# start nfet_03v3 ad=0.66p pd=3.64u as=0.305p ps=2.22u w=0.5u l=0.28u
X726 start a_18508_41600# a_19708_41600# start pfet_03v3 ad=1.38p pd=4.76u as=0.65p ps=3.3u w=1u l=0.28u
X727 start a_44108_12400# a_45308_12400# start pfet_03v3 ad=1.38p pd=4.76u as=0.65p ps=3.3u w=1u l=0.28u
X728 start start a_44908_54400# start pfet_03v3 ad=1.104p pd=4.36u as=0.52p ps=2.9u w=0.8u l=0.28u
X729 start a_11308_29600# a_12694_28400# start nfet_03v3 ad=0.66p pd=3.64u as=0.305p ps=2.22u w=0.5u l=0.28u
X730 start a_35308_29600# a_35308_29600# start nfet_03v3 ad=0.66p pd=3.64u as=0.305p ps=2.22u w=0.5u l=0.28u
X731 start a_2228_20424# a_2108_20560# start nfet_03v3 ad=0.66p pd=3.64u as=0.305p ps=2.22u w=0.5u l=0.28u
X732 start a_50228_15064# a_49028_15064# start pfet_03v3 ad=1.38p pd=4.76u as=0.65p ps=3.3u w=1u l=0.28u
X733 start a_10628_10824# a_9308_10960# start pfet_03v3 ad=1.38p pd=4.76u as=0.65p ps=3.3u w=1u l=0.28u
X734 start dout[7] a_50508_50400# start nfet_03v3 ad=0.577p pd=3.52u as=0.2646p ps=2.1u w=0.42u l=0.28u
X735 a_43894_32400# a_41308_33600# a_43708_33600# start nfet_03v3 ad=0.305p pd=2.22u as=0.305p ps=2.22u w=0.5u l=0.28u
X736 start start start start nfet_03v3 ad=0.2646p pd=2.1u as=0 ps=0 w=0.42u l=2.4u
X737 start a_34628_3864# a_33428_3864# start nfet_03v3 ad=0.66p pd=3.64u as=0.305p ps=2.22u w=0.5u l=0.28u
X738 start a_49028_9464# a_47828_9464# start nfet_03v3 ad=0.66p pd=3.64u as=0.305p ps=2.22u w=0.5u l=0.28u
X739 start a_41708_1200# a_42908_1200# start nfet_03v3 ad=0.66p pd=3.64u as=0.305p ps=2.22u w=0.5u l=0.28u
X740 start a_33428_3864# a_33308_4000# start pfet_03v3 ad=1.38p pd=4.76u as=0.65p ps=3.3u w=1u l=0.28u
X741 start a_38228_9464# a_37028_9464# start pfet_03v3 ad=1.38p pd=4.76u as=0.65p ps=3.3u w=1u l=0.28u
X742 start a_23308_50400# a_23428_54264# start pfet_03v3 ad=1.38p pd=4.76u as=0.65p ps=3.3u w=1u l=0.28u
X743 start start a_2908_37600# start nfet_03v3 ad=0.66p pd=3.64u as=0.305p ps=2.22u w=0.5u l=0.28u
X744 start a_2908_33600# a_10108_33600# start nfet_03v3 ad=0.577p pd=3.52u as=0.2646p ps=2.1u w=0.42u l=0.28u
X745 start a_9828_54264# a_9828_54264# start pfet_03v3 ad=1.104p pd=4.36u as=0.52p ps=2.9u w=0.8u l=0.28u
X746 start a_49708_37600# a_50908_37600# start pfet_03v3 ad=1.38p pd=4.76u as=0.65p ps=3.3u w=1u l=0.28u
X747 start a_8108_10960# a_9308_10960# start pfet_03v3 ad=1.38p pd=4.76u as=0.65p ps=3.3u w=1u l=0.28u
X748 start a_9308_15760# a_11708_15760# start nfet_03v3 ad=0.66p pd=3.64u as=0.305p ps=2.22u w=0.5u l=0.28u
X749 start dac_in[6] dac_in[6] start nfet_03v3 ad=0.577p pd=3.52u as=0.2646p ps=2.1u w=0.42u l=0.28u
X750 start a_53828_15064# a_52628_15064# start nfet_03v3 ad=0.66p pd=3.64u as=0.305p ps=2.22u w=0.5u l=0.28u
X751 start a_59828_3864# a_58628_3864# start nfet_03v3 ad=0.66p pd=3.64u as=0.305p ps=2.22u w=0.5u l=0.28u
X752 start start a_33308_1200# start nfet_03v3 ad=0.66p pd=3.64u as=0.305p ps=2.22u w=0.5u l=0.28u
X753 start a_11308_41600# a_12508_41600# start pfet_03v3 ad=1.38p pd=4.76u as=0.65p ps=3.3u w=1u l=0.28u
X754 start a_35308_41600# a_38908_41600# start pfet_03v3 ad=1.38p pd=4.76u as=0.65p ps=3.3u w=1u l=0.28u
X755 start a_58628_3864# a_57428_3864# start pfet_03v3 ad=1.38p pd=4.76u as=0.65p ps=3.3u w=1u l=0.28u
X756 start a_34108_29600# a_41308_29600# start nfet_03v3 ad=0.577p pd=3.52u as=0.2646p ps=2.1u w=0.42u l=0.28u
X757 start comp_done a_2908_46000# start nfet_03v3 ad=0.66p pd=3.64u as=0.305p ps=2.22u w=0.5u l=0.28u
X758 start a_19708_37600# dout[2] start nfet_03v3 ad=0.577p pd=3.52u as=0.2646p ps=2.1u w=0.42u l=0.28u
X759 start a_34628_9464# a_33428_9464# start nfet_03v3 ad=0.66p pd=3.64u as=0.305p ps=2.22u w=0.5u l=0.28u
X760 start a_49708_41600# a_51094_40400# start nfet_03v3 ad=0.66p pd=3.64u as=0.305p ps=2.22u w=0.5u l=0.28u
X761 start start a_17308_1360# start pfet_03v3 ad=1.38p pd=4.76u as=0.65p ps=3.3u w=1u l=0.28u
X762 start a_51308_6800# a_52508_6800# start pfet_03v3 ad=1.38p pd=4.76u as=0.65p ps=3.3u w=1u l=0.28u
X763 a_16108_10960# a_14908_10960# a_17308_10960# start pfet_03v3 ad=0.65p pd=3.3u as=0.65p ps=3.3u w=1u l=0.28u
X764 a_46294_49200# a_43708_50400# a_43828_54264# start nfet_03v3 ad=0.305p pd=2.22u as=0.305p ps=2.22u w=0.5u l=0.28u
X765 start a_41708_12400# a_42908_12400# start nfet_03v3 ad=0.66p pd=3.64u as=0.305p ps=2.22u w=0.5u l=0.28u
X766 start a_30228_54264# a_30228_54264# start nfet_03v3 ad=0.577p pd=3.52u as=0.2646p ps=2.1u w=0.42u l=0.28u
X767 start a_51308_1200# a_52508_1200# start nfet_03v3 ad=0.66p pd=3.64u as=0.305p ps=2.22u w=0.5u l=0.28u
X768 start a_39428_3864# a_38228_3864# start nfet_03v3 ad=0.66p pd=3.64u as=0.305p ps=2.22u w=0.5u l=0.28u
X769 start dout[2] a_11308_37600# start pfet_03v3 ad=1.104p pd=4.36u as=0.52p ps=2.9u w=0.8u l=0.28u
X770 start a_38228_3864# a_37028_3864# start pfet_03v3 ad=1.38p pd=4.76u as=0.65p ps=3.3u w=1u l=0.28u
X771 start a_18508_6160# a_17308_6160# start nfet_03v3 ad=0.577p pd=3.52u as=0.2646p ps=2.1u w=0.42u l=2.4u
X772 start a_17308_15760# a_18508_15760# start nfet_03v3 ad=0.66p pd=3.64u as=0.305p ps=2.22u w=0.5u l=0.28u
X773 start a_59828_9464# a_58628_9464# start nfet_03v3 ad=0.66p pd=3.64u as=0.305p ps=2.22u w=0.5u l=0.28u
X774 start a_4108_46000# a_5308_46000# start pfet_03v3 ad=1.38p pd=4.76u as=0.65p ps=3.3u w=1u l=0.28u
X775 start a_34108_41600# a_41308_41600# start pfet_03v3 ad=1.104p pd=4.36u as=0.52p ps=2.9u w=0.8u l=0.28u
X776 start a_41708_6800# a_42908_6800# start nfet_03v3 ad=0.66p pd=3.64u as=0.305p ps=2.22u w=0.5u l=0.28u
X777 start a_9308_6160# a_11708_6160# start pfet_03v3 ad=1.38p pd=4.76u as=0.65p ps=3.3u w=1u l=0.28u
X778 start comp_out_p a_17308_33600# start pfet_03v3 ad=1.104p pd=4.36u as=0.52p ps=2.9u w=0.8u l=0.28u
X779 start a_16228_6024# a_16108_6160# start pfet_03v3 ad=1.38p pd=4.76u as=0.65p ps=3.3u w=1u l=0.28u
X780 start a_51708_54400# dac_in[7] start pfet_03v3 ad=1.38p pd=4.76u as=0.65p ps=3.3u w=1u l=0.28u
X781 start dout[3] a_11308_41600# start nfet_03v3 ad=0.577p pd=3.52u as=0.2646p ps=2.1u w=0.42u l=0.28u
X782 start a_17308_10960# a_18508_10960# start nfet_03v3 ad=0.66p pd=3.64u as=0.305p ps=2.22u w=0.5u l=0.28u
X783 start a_34508_12400# a_35708_12400# start nfet_03v3 ad=0.66p pd=3.64u as=0.305p ps=2.22u w=0.5u l=0.28u
X784 start a_2908_54400# dac_in[0] start pfet_03v3 ad=1.38p pd=4.76u as=0.65p ps=3.3u w=1u l=0.28u
X785 start dout[2] a_16508_50400# start nfet_03v3 ad=0.577p pd=3.52u as=0.2646p ps=2.1u w=0.42u l=0.28u
X786 start a_51308_1200# a_52508_1200# start pfet_03v3 ad=1.38p pd=4.76u as=0.65p ps=3.3u w=1u l=0.28u
X787 start a_39428_9464# a_38228_9464# start nfet_03v3 ad=0.66p pd=3.64u as=0.305p ps=2.22u w=0.5u l=0.28u
X788 start a_18508_15760# a_17308_15760# start pfet_03v3 ad=0.6034p pd=3.64u as=0.2822p ps=2.18u w=0.42u l=2u
X789 start a_56108_6800# a_57308_6800# start pfet_03v3 ad=1.38p pd=4.76u as=0.65p ps=3.3u w=1u l=0.28u
X790 start a_35308_29600# a_48508_29600# start pfet_03v3 ad=1.104p pd=4.36u as=0.52p ps=2.9u w=0.8u l=0.28u
X791 start a_12508_29600# dout[0] start pfet_03v3 ad=1.104p pd=4.36u as=0.52p ps=2.9u w=0.8u l=0.28u
X792 start a_42508_33600# a_43708_33600# start pfet_03v3 ad=1.38p pd=4.76u as=0.65p ps=3.3u w=1u l=0.28u
X793 start a_61028_9464# a_59828_9464# start pfet_03v3 ad=1.38p pd=4.76u as=0.65p ps=3.3u w=1u l=0.28u
X794 start dout[6] a_42508_37600# start nfet_03v3 ad=0.577p pd=3.52u as=0.2646p ps=2.1u w=0.42u l=0.28u
X795 start start a_24508_54400# start pfet_03v3 ad=1.104p pd=4.36u as=0.52p ps=2.9u w=0.8u l=0.28u
X796 start a_10908_54400# dac_in[1] start pfet_03v3 ad=1.38p pd=4.76u as=0.65p ps=3.3u w=1u l=0.28u
X797 start dout[0] a_18508_29600# start nfet_03v3 ad=0.577p pd=3.52u as=0.2646p ps=2.1u w=0.42u l=0.28u
X798 start a_5708_20560# a_4508_20560# start nfet_03v3 ad=0.577p pd=3.52u as=0.2646p ps=2.1u w=0.42u l=2.4u
X799 start a_55028_15064# a_53828_15064# start pfet_03v3 ad=1.38p pd=4.76u as=0.65p ps=3.3u w=1u l=0.28u
X800 start a_50628_54264# a_50628_54264# start nfet_03v3 ad=0.577p pd=3.52u as=0.2646p ps=2.1u w=0.42u l=0.28u
X801 start comp_out_p a_48508_33600# start nfet_03v3 ad=0.577p pd=3.52u as=0.2646p ps=2.1u w=0.42u l=0.28u
X802 start a_52508_6800# a_53708_6800# start nfet_03v3 ad=0.66p pd=3.64u as=0.305p ps=2.22u w=0.5u l=0.28u
X803 start a_35708_6800# a_36908_6800# start pfet_03v3 ad=1.38p pd=4.76u as=0.65p ps=3.3u w=1u l=0.28u
X804 a_3308_6160# a_2228_6024# a_4508_6160# start nfet_03v3 ad=0.305p pd=2.22u as=0.305p ps=2.22u w=0.5u l=0.28u
X805 start a_12508_33600# dout[1] start nfet_03v3 ad=0.577p pd=3.52u as=0.2646p ps=2.1u w=0.42u l=0.28u
X806 start a_4108_50400# a_5494_49200# start nfet_03v3 ad=0.66p pd=3.64u as=0.305p ps=2.22u w=0.5u l=0.28u
X807 start a_51308_12400# a_52508_12400# start pfet_03v3 ad=1.38p pd=4.76u as=0.65p ps=3.3u w=1u l=0.28u
X808 start a_58628_15064# a_57428_15064# start nfet_03v3 ad=0.66p pd=3.64u as=0.305p ps=2.22u w=0.5u l=0.28u
X809 start a_56108_1200# a_57308_1200# start pfet_03v3 ad=1.38p pd=4.76u as=0.65p ps=3.3u w=1u l=0.28u
X810 start a_3028_54264# a_2908_54400# start nfet_03v3 ad=0.577p pd=3.52u as=0.2646p ps=2.1u w=0.42u l=0.28u
X811 start dout[3] a_18508_41600# start pfet_03v3 ad=1.104p pd=4.36u as=0.52p ps=2.9u w=0.8u l=0.28u
X812 start a_33428_6664# a_33308_6800# start nfet_03v3 ad=0.66p pd=3.64u as=0.305p ps=2.22u w=0.5u l=0.28u
X813 start a_43708_29600# dout[4] start nfet_03v3 ad=0.577p pd=3.52u as=0.2646p ps=2.1u w=0.42u l=0.28u
X814 start a_61028_3864# a_59828_3864# start pfet_03v3 ad=1.38p pd=4.76u as=0.65p ps=3.3u w=1u l=0.28u
X815 start a_3428_10824# a_3308_10960# start nfet_03v3 ad=0.66p pd=3.64u as=0.305p ps=2.22u w=0.5u l=0.28u
X816 start a_47828_15064# a_46628_15064# start pfet_03v3 ad=1.38p pd=4.76u as=0.65p ps=3.3u w=1u l=0.28u
X817 start a_9828_54264# a_9828_54264# start nfet_03v3 ad=0.577p pd=3.52u as=0.2646p ps=2.1u w=0.42u l=0.28u
X818 a_25894_49200# a_23308_50400# a_23428_54264# start nfet_03v3 ad=0.305p pd=2.22u as=0.305p ps=2.22u w=0.5u l=0.28u
X819 start a_10108_46000# a_11308_46000# start pfet_03v3 ad=1.38p pd=4.76u as=0.65p ps=3.3u w=1u l=0.28u
X820 start dout[6] a_49708_37600# start pfet_03v3 ad=1.104p pd=4.36u as=0.52p ps=2.9u w=0.8u l=0.28u
X821 start comp_out_p a_35308_29600# start pfet_03v3 ad=1.38p pd=4.76u as=0.65p ps=3.3u w=1u l=0.28u
X822 start a_35708_1200# a_36908_1200# start pfet_03v3 ad=1.38p pd=4.76u as=0.65p ps=3.3u w=1u l=0.28u
X823 start start a_10908_54400# start nfet_03v3 ad=0.577p pd=3.52u as=0.2646p ps=2.1u w=0.42u l=0.28u
X824 start start start start nfet_03v3 ad=0.2646p pd=2.1u as=0 ps=0 w=0.42u l=0.28u
X825 start a_42908_1200# a_44108_1200# start nfet_03v3 ad=0.66p pd=3.64u as=0.305p ps=2.22u w=0.5u l=0.28u
X826 a_9494_4800# a_8108_6160# a_9308_6160# start nfet_03v3 ad=0.305p pd=2.22u as=0.305p ps=2.22u w=0.5u l=0.28u
X827 start a_57308_6800# a_58508_6800# start nfet_03v3 ad=0.66p pd=3.64u as=0.305p ps=2.22u w=0.5u l=0.28u
X828 start a_43708_41600# dout[7] start pfet_03v3 ad=1.104p pd=4.36u as=0.52p ps=2.9u w=0.8u l=0.28u
X829 a_22294_4800# a_20908_6160# a_22108_6160# start nfet_03v3 ad=0.305p pd=2.22u as=0.305p ps=2.22u w=0.5u l=0.28u
X830 start a_46508_6800# a_47708_6800# start pfet_03v3 ad=1.38p pd=4.76u as=0.65p ps=3.3u w=1u l=0.28u
X831 start a_35708_12400# a_36908_12400# start pfet_03v3 ad=1.38p pd=4.76u as=0.65p ps=3.3u w=1u l=0.28u
X832 start a_51428_9464# a_50228_9464# start pfet_03v3 ad=1.38p pd=4.76u as=0.65p ps=3.3u w=1u l=0.28u
X833 start start dac_in[4] start pfet_03v3 ad=1.38p pd=4.76u as=0.65p ps=3.3u w=1u l=0.28u
X834 start a_19708_1360# a_20908_1360# start nfet_03v3 ad=0.66p pd=3.64u as=0.305p ps=2.22u w=0.5u l=0.28u
X835 start a_22108_10960# a_24508_10960# start pfet_03v3 ad=1.38p pd=4.76u as=0.65p ps=3.3u w=1u l=0.28u
X836 a_19894_36400# a_17308_37600# a_19708_37600# start nfet_03v3 ad=0.305p pd=2.22u as=0.305p ps=2.22u w=0.5u l=0.28u
X837 start comp_out_p comp_out_p start pfet_03v3 ad=1.38p pd=4.76u as=0.65p ps=3.3u w=1u l=0.28u
X838 start a_39708_24800# rst_latch start pfet_03v3 ad=1.38p pd=4.76u as=0.65p ps=3.3u w=1u l=0.28u
X839 start a_48908_12400# a_50108_12400# start nfet_03v3 ad=0.66p pd=3.64u as=0.305p ps=2.22u w=0.5u l=0.28u
X840 start dout[7] a_49708_41600# start nfet_03v3 ad=0.577p pd=3.52u as=0.2646p ps=2.1u w=0.42u l=0.28u
X841 start a_33308_1200# a_34508_1200# start nfet_03v3 ad=0.66p pd=3.64u as=0.305p ps=2.22u w=0.5u l=0.28u
X842 a_35494_32400# comp_out_p comp_out_p start nfet_03v3 ad=0.305p pd=2.22u as=0.305p ps=2.22u w=0.5u l=0.28u
X843 start a_36908_6800# a_38108_6800# start nfet_03v3 ad=0.66p pd=3.64u as=0.305p ps=2.22u w=0.5u l=0.28u
X844 a_5708_10960# a_2108_10960# a_8108_10960# start nfet_03v3 ad=0.305p pd=2.22u as=0.305p ps=2.22u w=0.5u l=0.28u
X845 a_18508_10960# a_14908_10960# a_20908_10960# start nfet_03v3 ad=0.305p pd=2.22u as=0.305p ps=2.22u w=0.5u l=0.28u
X846 start a_22108_15760# a_20908_15760# start nfet_03v3 ad=0.577p pd=3.52u as=0.2646p ps=2.1u w=0.42u l=2.4u
X847 start a_45428_15064# a_44228_15064# start nfet_03v3 ad=0.66p pd=3.64u as=0.305p ps=2.22u w=0.5u l=0.28u
X848 start a_18508_46000# a_19708_46000# start nfet_03v3 ad=0.66p pd=3.64u as=0.305p ps=2.22u w=0.5u l=0.28u
X849 start start a_2908_29600# start pfet_03v3 ad=1.38p pd=4.76u as=0.65p ps=3.3u w=1u l=0.28u
X850 start a_9308_20560# a_8108_20560# start nfet_03v3 ad=0.577p pd=3.52u as=0.2646p ps=2.1u w=0.42u l=2.4u
X851 start a_52508_1200# a_53708_1200# start nfet_03v3 ad=0.66p pd=3.64u as=0.305p ps=2.22u w=0.5u l=0.28u
X852 start a_46508_1200# a_47708_1200# start pfet_03v3 ad=1.38p pd=4.76u as=0.65p ps=3.3u w=1u l=0.28u
X853 start a_52628_3864# a_51428_3864# start nfet_03v3 ad=0.66p pd=3.64u as=0.305p ps=2.22u w=0.5u l=0.28u
X854 start comp_out_p a_44908_50400# start pfet_03v3 ad=1.104p pd=4.36u as=0.52p ps=2.9u w=0.8u l=0.28u
X855 start a_51428_3864# a_50228_3864# start pfet_03v3 ad=1.38p pd=4.76u as=0.65p ps=3.3u w=1u l=0.28u
X856 start a_56228_9464# a_55028_9464# start pfet_03v3 ad=1.38p pd=4.76u as=0.65p ps=3.3u w=1u l=0.28u
X857 start a_3428_10824# a_3308_10960# start pfet_03v3 ad=1.38p pd=4.76u as=0.65p ps=3.3u w=1u l=0.28u
X858 start a_17708_54400# a_19094_53200# start nfet_03v3 ad=0.66p pd=3.64u as=0.305p ps=2.22u w=0.5u l=0.28u
X859 start start start start nfet_03v3 ad=0.2646p pd=2.1u as=0 ps=0 w=0.42u l=0.28u
X860 start comp_out_p comp_out_p start pfet_03v3 ad=1.38p pd=4.76u as=0.65p ps=3.3u w=1u l=0.28u
X861 start a_19708_29600# dout[0] start pfet_03v3 ad=1.104p pd=4.36u as=0.52p ps=2.9u w=0.8u l=0.28u
X862 start a_4508_20560# a_5708_20560# start pfet_03v3 ad=1.38p pd=4.76u as=0.65p ps=3.3u w=1u l=0.28u
X863 start start a_2908_33600# start nfet_03v3 ad=0.66p pd=3.64u as=0.305p ps=2.22u w=0.5u l=0.28u
X864 start a_49708_33600# a_50908_33600# start pfet_03v3 ad=1.38p pd=4.76u as=0.65p ps=3.3u w=1u l=0.28u
X865 a_3308_15760# a_2228_15624# a_4508_15760# start nfet_03v3 ad=0.305p pd=2.22u as=0.305p ps=2.22u w=0.5u l=0.28u
X866 start a_56108_12400# a_57308_12400# start pfet_03v3 ad=1.38p pd=4.76u as=0.65p ps=3.3u w=1u l=0.28u
X867 start a_52628_9464# a_51428_9464# start nfet_03v3 ad=0.66p pd=3.64u as=0.305p ps=2.22u w=0.5u l=0.28u
X868 start a_41828_9464# a_40628_9464# start pfet_03v3 ad=1.38p pd=4.76u as=0.65p ps=3.3u w=1u l=0.28u
X869 start comp_out_p a_35494_40400# start nfet_03v3 ad=0.66p pd=3.64u as=0.305p ps=2.22u w=0.5u l=0.28u
X870 start a_19708_33600# dout[1] start nfet_03v3 ad=0.577p pd=3.52u as=0.2646p ps=2.1u w=0.42u l=0.28u
X871 a_18508_15760# a_15028_15624# a_20908_15760# start pfet_03v3 ad=0.65p pd=3.3u as=0.65p ps=3.3u w=1u l=0.28u
X872 start start start start pfet_03v3 ad=0.2822p pd=2.18u as=0 ps=0 w=0.42u l=2u
X873 start a_14908_46000# a_16108_46000# start pfet_03v3 ad=1.38p pd=4.76u as=0.65p ps=3.3u w=1u l=0.28u
X874 start a_57428_3864# a_56228_3864# start nfet_03v3 ad=0.66p pd=3.64u as=0.305p ps=2.22u w=0.5u l=0.28u
X875 start a_24508_54400# a_25894_53200# start nfet_03v3 ad=0.66p pd=3.64u as=0.305p ps=2.22u w=0.5u l=0.28u
X876 start start a_38108_54400# start nfet_03v3 ad=0.577p pd=3.52u as=0.2646p ps=2.1u w=0.42u l=0.28u
X877 start a_56228_3864# a_55028_3864# start pfet_03v3 ad=1.38p pd=4.76u as=0.65p ps=3.3u w=1u l=0.28u
X878 start a_4508_15760# a_5708_15760# start pfet_03v3 ad=1.38p pd=4.76u as=0.65p ps=3.3u w=1u l=0.28u
X879 start a_2228_1424# start start nfet_03v3 ad=0.2646p pd=2.1u as=0 ps=0 w=0.42u l=0.28u
X880 start comp_out_p comp_out_p start pfet_03v3 ad=1.38p pd=4.76u as=0.65p ps=3.3u w=1u l=0.28u
X881 start dout[1] a_11308_33600# start pfet_03v3 ad=1.104p pd=4.36u as=0.52p ps=2.9u w=0.8u l=0.28u
X882 start a_59708_6800# a_60908_6800# start nfet_03v3 ad=0.66p pd=3.64u as=0.305p ps=2.22u w=0.5u l=0.28u
X883 start a_50908_29600# dout[4] start nfet_03v3 ad=0.577p pd=3.52u as=0.2646p ps=2.1u w=0.42u l=0.28u
X884 start a_48908_6800# a_50108_6800# start pfet_03v3 ad=1.38p pd=4.76u as=0.65p ps=3.3u w=1u l=0.28u
X885 start start a_34108_37600# start nfet_03v3 ad=0.66p pd=3.64u as=0.305p ps=2.22u w=0.5u l=0.28u
X886 start a_51708_50400# a_50628_54264# start pfet_03v3 ad=1.38p pd=4.76u as=0.65p ps=3.3u w=1u l=0.28u
X887 start a_37028_3864# a_35828_3864# start nfet_03v3 ad=0.66p pd=3.64u as=0.305p ps=2.22u w=0.5u l=0.28u
X888 start a_53708_12400# a_54908_12400# start nfet_03v3 ad=0.66p pd=3.64u as=0.305p ps=2.22u w=0.5u l=0.28u
X889 a_16108_6160# a_15028_6024# a_17308_6160# start nfet_03v3 ad=0.305p pd=2.22u as=0.305p ps=2.22u w=0.5u l=0.28u
X890 start a_38108_54400# a_39494_53200# start nfet_03v3 ad=0.66p pd=3.64u as=0.305p ps=2.22u w=0.5u l=0.28u
X891 start start a_51708_54400# start nfet_03v3 ad=0.577p pd=3.52u as=0.2646p ps=2.1u w=0.42u l=0.28u
X892 start comp_out_p comp_out_p start nfet_03v3 ad=0.66p pd=3.64u as=0.305p ps=2.22u w=0.5u l=0.28u
X893 start dout[4] a_42508_29600# start pfet_03v3 ad=1.104p pd=4.36u as=0.52p ps=2.9u w=0.8u l=0.28u
X894 start comp_done a_43094_18000# start nfet_03v3 ad=0.66p pd=3.64u as=0.305p ps=2.22u w=0.5u l=0.28u
X895 start a_57428_9464# a_56228_9464# start nfet_03v3 ad=0.66p pd=3.64u as=0.305p ps=2.22u w=0.5u l=0.28u
X896 start a_41828_3864# a_40628_3864# start pfet_03v3 ad=1.38p pd=4.76u as=0.65p ps=3.3u w=1u l=0.28u
X897 start a_46628_9464# a_45428_9464# start pfet_03v3 ad=1.38p pd=4.76u as=0.65p ps=3.3u w=1u l=0.28u
X898 a_4294_40400# comp_out_p a_4108_41600# start nfet_03v3 ad=0.305p pd=2.22u as=0.305p ps=2.22u w=0.5u l=0.28u
X899 start a_53708_1200# a_54908_1200# start nfet_03v3 ad=0.66p pd=3.64u as=0.305p ps=2.22u w=0.5u l=0.28u
C0 a_48508_37600# rst_latch 0.02515f
C1 a_17308_46000# dout[0] 0.03722f
C2 a_33308_24800# dac_in[6] 0.12595f
C3 a_49708_33600# a_50908_33600# 0.76551f
C4 a_2228_15624# a_3428_15624# 0.03237f
C5 dac_in[0] a_4108_54400# 0.80903f
C6 comp_out_p a_19094_49200# 0.0216f
C7 dac_in[5] a_3028_54264# 0.13525f
C8 dac_in[1] a_37028_54264# 0.12915f
C9 dout[6] a_42508_41600# 0.04175f
C10 a_50628_54264# dout[7] 3.97166f
C11 comp_out_p a_17308_29600# 1.03478f
C12 a_46508_12400# a_48908_12400# 0.04266f
C13 a_14908_15760# a_17308_15760# 1.27786f
C14 a_19894_28400# a_18508_29600# 0.0129f
C15 a_50108_12400# a_51308_12400# 1.00702f
C16 a_38908_41600# a_33308_24800# 0.06767f
C17 a_2108_15760# comp_out_p 0.03507f
C18 a_17308_41600# dout[2] 0.13354f
C19 a_47708_6800# a_48908_6800# 1.00702f
C20 a_19894_36400# a_19708_37600# 0.03264f
C21 a_5308_46000# a_7708_46000# 0.04266f
C22 dout[1] a_12508_37600# 0.03546f
C23 dout[0] comp_out_p 2.99553f
C24 dout[3] a_14908_46000# 0.04148f
C25 dout[1] a_47028_19064# 0.12157f
C26 a_17308_46000# a_19708_46000# 0.04266f
C27 a_33308_24800# dac_in[0] 0.12157f
C28 a_33308_19200# a_34108_37600# 0.01826f
C29 a_24508_15760# a_22108_15760# 1.03812f
C30 a_9308_15760# a_11708_15760# 1.03812f
C31 a_34108_41600# a_42508_41600# 0.04546f
C32 comp_out_p a_7708_46000# 0.12179f
C33 dout[4] sample_en 0.29287f
C34 dout[7] a_37028_54264# 0.12915f
C35 a_3028_54264# a_10908_54400# 0.02661f
C36 a_47028_19064# a_49708_33600# 0.01969f
C37 comp_out_p a_38108_50400# 0.08383f
C38 rst_latch a_16628_54264# 0.12157f
C39 done a_9828_54264# 0.12835f
C40 a_58628_15064# a_59828_15064# 0.90775f
C41 a_16108_15760# a_35308_29600# 0.03541f
C42 a_50108_12400# a_47708_12400# 0.04266f
C43 a_16108_46000# dout[0] 0.01835f
C44 rst_latch dout[3] 0.12835f
C45 a_20908_46000# a_43708_41600# 0.03128f
C46 sample_en a_51708_54400# 0.01776f
C47 a_48508_33600# a_50908_33600# 0.99858f
C48 a_33308_24800# dout[6] 0.50537f
C49 comp_out_p a_12294_49200# 0.01168f
C50 rst_latch a_43828_54264# 0.30356f
C51 a_19708_46000# comp_out_p 0.01977f
C52 a_33308_24800# a_36908_54400# 0.01467f
C53 a_16508_54400# comp_out_p 0.02217f
C54 a_16508_50400# dout[0] 0.02074f
C55 a_16228_15624# a_17308_15760# 0.04931f
C56 dout[5] a_3028_54264# 0.12915f
C57 a_34108_41600# a_33308_24800# 0.22913f
C58 a_46508_12400# a_47708_12400# 1.00762f
C59 a_3428_15624# comp_out_p 0.02118f
C60 a_11308_37600# a_12508_37600# 0.76551f
C61 a_12508_41600# dout[2] 0.03546f
C62 a_24508_10960# a_22108_10960# 1.03812f
C63 a_19894_36400# a_18508_37600# 0.0129f
C64 a_33308_19200# a_2908_37600# 0.01463f
C65 dout[1] a_11308_37600# 0.04175f
C66 a_17308_15760# comp_out_p 0.03758f
C67 a_17308_46000# a_18508_46000# 1.00702f
C68 a_10628_15624# a_11708_15760# 0.04888f
C69 dout[6] a_50908_41600# 0.07038f
C70 a_49028_3864# a_50228_3864# 0.90775f
C71 dout[0] dac_in[2] 0.06141f
C72 sample_en dac_in[5] 0.21432f
C73 a_47028_19064# a_48508_33600# 0.02674f
C74 done dac_in[6] 0.12286f
C75 comp_done dac_in[7] 0.07032f
C76 comp_done a_30228_54264# 0.2692f
C77 dout[5] a_50508_50400# 0.0187f
C78 dout[2] a_33308_19200# 0.12341f
C79 a_50628_54264# a_33308_24800# 0.2519f
C80 a_38908_41600# a_49708_41600# 0.04546f
C81 rst_latch dac_in[4] 0.06756f
C82 a_19708_33600# dout[0] 0.03072f
C83 a_48508_33600# a_49708_33600# 0.42399f
C84 a_3308_20560# comp_out_p 0.02746f
C85 dout[0] a_2908_50400# 1.01498f
C86 a_18508_46000# comp_out_p 0.03627f
C87 a_33308_24800# a_37028_54264# 0.74597f
C88 a_49708_29600# a_35308_29600# 0.04546f
C89 a_45308_12400# a_47708_12400# 0.04266f
C90 a_16228_15624# a_14908_15760# 0.02521f
C91 a_35308_41600# a_33308_24800# 0.01323f
C92 a_12508_29600# dout[0] 1.09037f
C93 dac_in[1] comp_done 0.06079f
C94 dac_in[0] done 0.06079f
C95 a_44908_50400# a_43828_54264# 0.80903f
C96 a_16508_54400# dac_in[2] 0.99858f
C97 a_2228_15624# comp_out_p 0.04802f
C98 a_11308_41600# dout[2] 0.04175f
C99 a_24508_10960# a_23428_10824# 0.04888f
C100 a_10108_37600# a_12508_37600# 0.99858f
C101 dout[1] a_10108_37600# 0.05122f
C102 dout[3] a_12508_46000# 0.04109f
C103 a_10908_54400# a_9708_54400# 0.42392f
C104 a_16108_46000# a_18508_46000# 0.04266f
C105 a_50508_54400# done 0.02312f
C106 a_14908_15760# comp_out_p 0.06715f
C107 a_8108_15760# a_11708_15760# 0.04749f
C108 dout[6] a_49708_41600# 0.0602f
C109 a_15028_15624# a_22108_15760# 0.07546f
C110 a_7708_41600# dout[0] 0.07935f
C111 a_20908_46000# rst_latch 0.23145f
C112 a_36908_6800# a_34508_6800# 0.04266f
C113 a_44908_54400# a_35308_29600# 0.01926f
C114 dout[7] comp_done 0.37662f
C115 dout[6] done 0.21603f
C116 dout[5] sample_en 0.70269f
C117 dac_in[3] a_33308_19200# 0.06756f
C118 a_38908_41600# a_48508_41600# 1.00186f
C119 a_41308_41600# a_43708_41600# 0.99858f
C120 a_18508_33600# dout[0] 0.05324f
C121 a_35894_23600# sample_en 0.0201f
C122 a_19894_40400# a_19708_41600# 0.03264f
C123 dout[4] a_50908_29600# 1.09035f
C124 a_34108_41600# done 0.02648f
C125 a_10908_50400# a_12294_49200# 0.0129f
C126 a_48508_29600# a_35308_29600# 1.00186f
C127 a_10628_20424# a_9308_20560# 0.26034f
C128 a_16628_54264# a_19094_49200# 0.03268f
C129 a_11308_29600# dout[0] 1.03879f
C130 a_45308_12400# a_46508_12400# 1.00702f
C131 a_33308_19200# a_35308_29600# 0.18857f
C132 a_43708_50400# a_43828_54264# 0.99858f
C133 a_10108_41600# dout[2] 0.05122f
C134 a_24508_10960# a_20908_10960# 0.04749f
C135 a_22108_10960# a_22294_9600# 0.03324f
C136 a_10108_37600# a_11308_37600# 0.42399f
C137 dout[1] a_19708_37600# 0.03072f
C138 dac_in[7] a_3028_54264# 25.7338f
C139 a_16108_46000# a_17308_46000# 1.00762f
C140 a_16228_15624# comp_out_p 0.01659f
C141 a_50628_54264# done 0.20219f
C142 dout[6] a_48508_41600# 0.12446f
C143 comp_out_p a_5308_46000# 0.0157f
C144 a_8108_15760# a_5708_15760# 0.46956f
C145 a_3028_54264# a_30228_54264# 0.1361f
C146 a_2108_20560# a_33308_19200# 0.02806f
C147 a_38228_3864# a_39428_3864# 0.90778f
C148 a_34108_37600# a_41308_37600# 1.00249f
C149 dout[0] a_16628_54264# 3.14848f
C150 a_35708_6800# a_34508_6800# 1.00762f
C151 a_43708_54400# a_35308_29600# 0.02324f
C152 comp_done a_4108_54400# 0.02742f
C153 dout[2] a_12508_37600# 1.09037f
C154 a_34108_33600# a_41308_33600# 1.00249f
C155 a_45308_12400# a_42908_12400# 0.04266f
C156 dout[2] a_47028_19064# 0.12341f
C157 dout[0] dout[3] 0.24079f
C158 dout[1] dout[2] 31.125f
C159 a_35494_28400# comp_out_p 0.01992f
C160 a_20908_46000# a_44908_50400# 0.02716f
C161 a_23428_54264# a_33308_19200# 0.13273f
C162 a_17308_33600# dout[0] 0.14687f
C163 dout[4] a_51708_50400# 0.02765f
C164 done a_37028_54264# 0.12595f
C165 a_42908_19200# a_43094_18000# 0.042f
C166 dout[4] a_49708_29600# 1.03879f
C167 dout[0] a_43828_54264# 0.1156f
C168 a_35308_41600# done 0.0276f
C169 dac_in[1] a_3028_54264# 0.1475f
C170 a_16108_46000# comp_out_p 0.02477f
C171 a_4508_20560# a_3308_20560# 0.2837f
C172 a_34108_33600# comp_out_p 1.65393f
C173 a_8108_20560# a_9308_20560# 2.73702f
C174 a_41708_12400# a_42908_12400# 1.00762f
C175 a_44108_12400# a_46508_12400# 0.04266f
C176 rst_latch a_9828_54264# 0.12835f
C177 a_33308_24800# comp_done 0.56495f
C178 a_10108_29600# dout[0] 0.03674f
C179 a_18508_10960# a_20908_10960# 0.46956f
C180 a_4108_46000# a_5308_46000# 1.00762f
C181 a_5708_10960# a_3308_10960# 0.06606f
C182 a_16508_54400# a_16628_54264# 1.03164f
C183 a_2908_37600# a_11308_37600# 0.04546f
C184 a_19708_46000# dout[3] 0.04398f
C185 a_16508_50400# comp_out_p 0.07438f
C186 a_16508_54400# dout[3] 0.02601f
C187 dout[1] a_18508_37600# 0.05997f
C188 a_4108_50400# dout[0] 0.07275f
C189 a_4508_15760# a_5708_15760# 1.81793f
C190 dout[6] a_43708_41600# 0.03546f
C191 a_18508_15760# a_15028_15624# 0.76262f
C192 a_40908_24800# sample_en 0.0275f
C193 dout[7] a_3028_54264# 0.12915f
C194 a_35708_6800# a_33308_6800# 0.04266f
C195 a_10628_6024# a_9308_6160# 0.26027f
C196 dout[2] a_11308_37600# 1.03879f
C197 a_44108_12400# a_42908_12400# 1.00702f
C198 a_20908_46000# a_43708_50400# 0.02107f
C199 dout[1] dac_in[3] 0.06119f
C200 comp_out_p dac_in[2] 0.4245f
C201 dac_in[3] a_47028_19064# 0.06756f
C202 dout[0] dac_in[4] 0.06119f
C203 sample_en dac_in[7] 0.17977f
C204 dout[4] a_48508_29600# 0.03674f
C205 dout[4] a_33308_19200# 0.12835f
C206 dout[7] a_50508_50400# 1.02198f
C207 a_49708_37600# comp_out_p 0.04546f
C208 sample_en a_30228_54264# 0.25867f
C209 a_17708_50400# a_19094_49200# 0.0129f
C210 rst_latch dac_in[6] 0.1281f
C211 a_19708_33600# comp_out_p 0.01936f
C212 a_40508_12400# a_42908_12400# 0.04266f
C213 a_8108_20560# a_10628_20424# 0.08029f
C214 a_47028_19064# a_35308_29600# 0.3557f
C215 dout[1] a_35308_29600# 0.1666f
C216 a_2908_29600# dout[0] 0.09997f
C217 a_44108_12400# a_45308_12400# 1.00762f
C218 a_20908_10960# a_22294_9600# 0.05987f
C219 a_18508_10960# a_17308_10960# 1.81793f
C220 a_2908_46000# a_5308_46000# 0.04266f
C221 a_2908_37600# a_10108_37600# 1.00249f
C222 a_49708_37600# a_50908_37600# 0.76551f
C223 comp_out_p a_2908_50400# 0.0238f
C224 a_18508_46000# dout[3] 0.03184f
C225 a_17708_50400# dout[0] 0.03827f
C226 a_20908_15760# a_22294_14400# 0.05987f
C227 a_2228_20424# a_33308_19200# 0.02937f
C228 dout[1] a_17308_37600# 0.13845f
C229 a_4508_15760# a_3308_15760# 0.2837f
C230 comp_out_p a_2908_46000# 0.02787f
C231 a_20908_46000# dout[0] 0.12835f
C232 a_3028_54264# a_4108_54400# 0.06294f
C233 a_39708_24800# sample_en 0.02869f
C234 a_53828_9464# a_55028_9464# 0.90775f
C235 a_37028_3864# a_38228_3864# 0.90775f
C236 a_12508_29600# comp_out_p 0.01611f
C237 a_15028_10824# a_22108_10960# 0.07546f
C238 dac_in[1] sample_en 0.12157f
C239 a_14908_10960# a_20908_10960# 0.29742f
C240 a_30228_54264# a_32694_49200# 0.03268f
C241 a_8108_6160# a_9308_6160# 2.73702f
C242 a_44108_12400# a_41708_12400# 0.04266f
C243 dout[2] a_10108_37600# 0.03674f
C244 comp_done a_49708_41600# 0.0193f
C245 dac_in[0] rst_latch 0.06079f
C246 a_10908_50400# comp_out_p 1.07137f
C247 a_15028_6024# a_35308_29600# 0.02786f
C248 a_23428_54264# dout[1] 0.12238f
C249 a_23428_54264# a_47028_19064# 0.13273f
C250 a_7708_41600# comp_out_p 0.49397f
C251 a_42508_33600# a_43708_33600# 0.76551f
C252 dac_in[1] a_9708_54400# 0.99858f
C253 a_4508_20560# comp_out_p 0.02401f
C254 dout[4] a_43708_29600# 1.09037f
C255 dout[5] a_51708_50400# 0.01851f
C256 a_33308_24800# a_3028_54264# 0.24315f
C257 a_48508_37600# comp_out_p 1.00186f
C258 dout[7] sample_en 3.77025f
C259 a_2108_6160# a_33308_19200# 0.02806f
C260 comp_done done 6.97623f
C261 a_18508_33600# comp_out_p 0.07684f
C262 dac_in[5] a_33308_19200# 0.06079f
C263 a_40508_12400# a_41708_12400# 1.00702f
C264 a_47708_1200# a_45308_1200# 0.04266f
C265 a_19708_46000# a_20908_46000# 0.92654f
C266 dout[4] a_50908_33600# 0.06896f
C267 a_41308_37600# a_35308_29600# 0.03334f
C268 rst_latch dout[6] 0.34999f
C269 a_35494_40400# a_35308_41600# 0.04392f
C270 a_23428_54264# a_24508_50400# 0.80903f
C271 a_48508_37600# a_50908_37600# 0.99858f
C272 a_2908_46000# a_4108_46000# 1.00709f
C273 a_4108_54400# a_2908_54400# 0.42392f
C274 a_16108_10960# a_17308_10960# 0.2837f
C275 a_17308_46000# dout[3] 0.0612f
C276 a_35708_24800# sample_en 0.93103f
C277 a_14908_10960# a_17308_10960# 1.27786f
C278 dout[2] a_2908_37600# 0.09997f
C279 a_8108_6160# a_10628_6024# 0.08029f
C280 a_12508_33600# dout[1] 1.09037f
C281 dout[2] a_19708_37600# 1.09035f
C282 a_4294_28400# comp_out_p 0.0636f
C283 a_9708_50400# comp_out_p 0.12922f
C284 sample_en a_42508_41600# 0.0229f
C285 comp_done a_48508_41600# 0.03074f
C286 a_2908_41600# comp_out_p 0.32105f
C287 comp_out_p a_16628_54264# 0.81028f
C288 dout[4] a_42508_29600# 1.03879f
C289 dout[1] dout[4] 0.12274f
C290 comp_out_p dout[3] 5.51066f
C291 a_50628_54264# rst_latch 0.13448f
C292 dout[4] a_47028_19064# 6.23051f
C293 a_18508_46000# a_20908_46000# 0.0399f
C294 a_39308_12400# a_41708_12400# 0.04266f
C295 a_46508_1200# a_45308_1200# 1.00702f
C296 dout[0] a_9828_54264# 0.12238f
C297 a_17308_33600# comp_out_p 1.0341f
C298 dout[5] a_33308_19200# 0.12157f
C299 a_34108_37600# a_35308_29600# 0.11376f
C300 dout[4] a_49708_33600# 0.07933f
C301 comp_out_p a_43828_54264# 1.20696f
C302 a_48508_37600# a_49708_37600# 0.42399f
C303 a_47028_19064# a_51708_54400# 0.01844f
C304 rst_latch a_37028_54264# 0.12595f
C305 dout[6] a_44908_50400# 0.04652f
C306 a_2108_20560# a_5708_20560# 0.4841f
C307 comp_out_p a_19094_53200# 0.0188f
C308 a_33308_24800# sample_en 26.9229f
C309 a_52628_9464# a_53828_9464# 0.90778f
C310 a_18508_37600# a_19708_37600# 0.76551f
C311 a_35828_3864# a_37028_3864# 0.90778f
C312 a_15028_10824# a_20908_10960# 0.34742f
C313 a_16228_10824# a_17308_10960# 0.04931f
C314 a_12694_28400# a_12508_29600# 0.03264f
C315 a_16508_50400# a_16628_54264# 0.99858f
C316 a_18508_33600# a_19708_33600# 0.76551f
C317 a_11308_33600# dout[1] 1.03879f
C318 a_2908_33600# a_33308_19200# 0.01463f
C319 a_9828_54264# a_12294_49200# 0.03268f
C320 a_23308_50400# comp_out_p 0.07976f
C321 dout[2] a_18508_37600# 1.03879f
C322 a_16508_50400# dout[3] 0.02601f
C323 a_15028_15624# a_35308_29600# 0.0232f
C324 a_4108_41600# comp_out_p 1.73113f
C325 a_4108_50400# comp_out_p 0.01771f
C326 done a_3028_54264# 0.12157f
C327 a_15028_6024# a_16108_6160# 0.25574f
C328 a_33308_19200# a_2228_1424# 0.03642f
C329 a_2228_6024# a_33308_19200# 0.02849f
C330 a_42508_37600# comp_out_p 0.01525f
C331 dac_in[2] a_16628_54264# 3.20678f
C332 dout[1] dac_in[5] 0.06032f
C333 dout[0] dac_in[6] 0.05879f
C334 comp_out_p dac_in[4] 0.69928f
C335 dac_in[5] a_47028_19064# 0.06099f
C336 dout[2] dac_in[3] 0.06119f
C337 a_58508_1200# a_59708_1200# 1.0077f
C338 dout[3] dac_in[2] 0.09969f
C339 a_46508_1200# a_44108_1200# 0.04266f
C340 a_39308_12400# a_40508_12400# 1.00762f
C341 dout[4] a_48508_33600# 0.12639f
C342 comp_out_p a_38108_54400# 0.08385f
C343 done a_50508_50400# 0.03275f
C344 a_11308_29600# a_12508_29600# 0.76551f
C345 dout[6] a_43708_50400# 1.01288f
C346 dout[5] a_50908_33600# 1.09035f
C347 dac_in[2] a_43828_54264# 0.12905f
C348 dout[2] a_35308_29600# 2.85702f
C349 a_2908_29600# comp_out_p 1.67882f
C350 a_10628_15624# a_9308_15760# 0.26027f
C351 a_17308_37600# a_19708_37600# 0.99858f
C352 a_4508_10960# a_3308_10960# 0.2837f
C353 dout[1] a_10908_54400# 0.02186f
C354 a_15028_10824# a_17308_10960# 0.24111f
C355 dac_in[2] a_19094_53200# 0.03268f
C356 a_12694_28400# a_11308_29600# 0.0129f
C357 a_17308_33600# a_19708_33600# 0.99858f
C358 a_39308_12400# a_36908_12400# 0.04266f
C359 a_10108_33600# dout[1] 0.03674f
C360 dac_in[0] dout[0] 0.08402f
C361 a_17708_50400# comp_out_p 1.03578f
C362 dout[2] a_17308_37600# 0.03674f
C363 a_20908_46000# comp_out_p 1.69239f
C364 a_9708_50400# a_10908_50400# 0.42392f
C365 a_33308_24800# a_43894_36400# 0.01137f
C366 a_2908_41600# a_7708_41600# 0.33005f
C367 a_35308_29600# a_36908_50400# 0.04976f
C368 a_7708_41600# dout[3] 1.26823f
C369 a_35708_12400# a_36908_12400# 1.00702f
C370 a_57308_1200# a_59708_1200# 0.04266f
C371 a_23428_54264# dout[2] 0.12238f
C372 dout[5] a_47028_19064# 0.31787f
C373 dout[0] dout[6] 0.11474f
C374 dout[1] dout[5] 0.11577f
C375 a_38108_12400# a_40508_12400# 0.04266f
C376 dac_in[2] dac_in[4] 0.06159f
C377 dout[4] a_43708_33600# 0.03546f
C378 comp_done a_34108_29600# 0.03012f
C379 done sample_en 0.28398f
C380 dout[7] a_51708_50400# 0.07171f
C381 a_39308_1200# a_38108_1200# 1.00702f
C382 a_10108_29600# a_12508_29600# 0.99858f
C383 dout[5] a_49708_33600# 1.03879f
C384 a_16508_50400# a_17708_50400# 0.42392f
C385 a_33308_19200# a_30228_54264# 0.16401f
C386 a_2228_20424# a_5708_20560# 0.76262f
C387 dac_in[7] a_33308_19200# 0.06756f
C388 a_4108_50400# a_2908_50400# 0.42392f
C389 a_17308_37600# a_18508_37600# 0.42399f
C390 a_19708_41600# comp_out_p 0.01936f
C391 a_34628_3864# a_35828_3864# 0.90775f
C392 a_8108_15760# a_9308_15760# 2.73702f
C393 a_2108_10960# a_3308_10960# 1.39926f
C394 a_51428_9464# a_52628_9464# 0.90775f
C395 rst_latch comp_done 5.57241f
C396 dac_in[3] a_35308_29600# 0.06119f
C397 a_17308_33600# a_18508_33600# 0.42399f
C398 a_38108_12400# a_36908_12400# 1.00762f
C399 a_2908_33600# dout[1] 0.09997f
C400 a_37028_9464# a_38228_9464# 0.90775f
C401 a_52628_15064# sample_en 0.01026f
C402 a_53708_1200# a_56108_1200# 0.04266f
C403 a_9308_6160# a_11708_6160# 1.03812f
C404 a_4108_41600# a_7708_41600# 1.36391f
C405 a_20908_46000# dac_in[2] 0.22829f
C406 a_50628_54264# dout[0] 0.12065f
C407 a_43828_54264# a_53094_53200# 0.01615f
C408 dac_in[1] a_33308_19200# 0.06079f
C409 a_2908_41600# dout[3] 0.09997f
C410 a_34508_12400# a_36908_12400# 0.04266f
C411 a_57308_1200# a_58508_1200# 1.00702f
C412 sample_en a_55028_15064# 0.01137f
C413 a_38108_12400# a_39308_12400# 1.00702f
C414 dout[3] a_16628_54264# 0.18645f
C415 a_23428_54264# dac_in[3] 3.29819f
C416 dout[5] a_41308_37600# 0.05122f
C417 dout[4] a_42508_33600# 0.04175f
C418 dout[2] dout[4] 0.12318f
C419 a_39308_1200# a_36908_1200# 0.04266f
C420 dout[0] a_37028_54264# 0.12238f
C421 a_10108_29600# a_11308_29600# 0.42399f
C422 dout[5] a_48508_33600# 0.03674f
C423 comp_out_p a_9828_54264# 4.88535f
C424 dout[7] a_33308_19200# 0.12157f
C425 a_3428_10824# a_3308_10960# 1.05947f
C426 a_16628_54264# a_43828_54264# 0.136f
C427 a_8108_15760# a_10628_15624# 0.08029f
C428 a_38108_50400# a_37028_54264# 0.81019f
C429 dout[3] a_43828_54264# 0.1156f
C430 a_23428_54264# a_35308_29600# 0.11997f
C431 a_38108_12400# a_35708_12400# 0.04266f
C432 a_39494_53200# a_38108_54400# 0.0129f
C433 a_10628_6024# a_11708_6160# 0.04888f
C434 a_41308_41600# comp_out_p 0.0869f
C435 a_18508_10960# comp_out_p 0.05074f
C436 a_53708_1200# a_54908_1200# 1.00762f
C437 a_4108_41600# a_2908_41600# 0.87222f
C438 a_51094_28400# a_50908_29600# 0.03264f
C439 a_23308_50400# dout[3] 1.04412f
C440 sample_en a_43708_41600# 0.0288f
C441 sample_en a_53828_15064# 0.05234f
C442 a_56108_1200# a_58508_1200# 0.04266f
C443 a_34508_12400# a_35708_12400# 1.00762f
C444 a_42508_37600# a_43708_37600# 0.76551f
C445 rst_latch a_3028_54264# 0.12157f
C446 dac_in[4] a_16628_54264# 0.13593f
C447 a_2908_29600# a_11308_29600# 0.04546f
C448 dout[4] dac_in[3] 0.06119f
C449 a_47028_19064# a_30228_54264# 0.13273f
C450 dout[1] dac_in[7] 0.06119f
C451 dout[5] a_43708_33600# 1.09037f
C452 comp_out_p dac_in[6] 0.43339f
C453 dout[1] a_30228_54264# 0.12238f
C454 dac_in[7] a_47028_19064# 0.06765f
C455 dout[2] dac_in[5] 0.06032f
C456 dout[3] dac_in[4] 0.06119f
C457 a_3428_20424# a_2108_20560# 0.02521f
C458 a_50228_9464# a_51428_9464# 0.90778f
C459 a_2228_10824# a_3308_10960# 0.25574f
C460 dac_in[3] a_24508_54400# 0.80903f
C461 dac_in[2] a_9828_54264# 0.13507f
C462 sample_en a_41308_29600# 0.02104f
C463 a_8108_6160# a_2108_6160# 0.29742f
C464 a_9308_6160# a_2228_6024# 0.07546f
C465 a_17708_54400# dout[1] 0.01884f
C466 done a_50908_29600# 0.0288f
C467 dac_in[4] a_43828_54264# 0.12905f
C468 a_38908_41600# comp_out_p 0.39729f
C469 dout[4] a_35308_29600# 1.39873f
C470 a_16108_10960# comp_out_p 0.02485f
C471 sample_en a_54908_6800# 0.01711f
C472 a_8108_6160# a_11708_6160# 0.04749f
C473 a_15028_6024# a_22108_6160# 0.07546f
C474 a_51094_28400# a_49708_29600# 0.0129f
C475 a_17708_50400# a_16628_54264# 0.80903f
C476 a_20908_46000# a_16628_54264# 2.05425f
C477 a_17708_50400# dout[3] 0.01279f
C478 dac_in[1] a_47028_19064# 0.06079f
C479 dac_in[0] comp_out_p 1.00548f
C480 dac_in[1] dout[1] 0.08964f
C481 a_33308_24800# a_33308_19200# 21.2876f
C482 a_16108_6160# a_35308_29600# 0.03818f
C483 a_14908_10960# comp_out_p 0.06715f
C484 a_56108_1200# a_57308_1200# 1.00762f
C485 a_33308_12400# a_35708_12400# 0.04266f
C486 a_43708_37600# a_20908_46000# 0.03128f
C487 a_20908_46000# dout[3] 0.12886f
C488 a_50508_54400# comp_out_p 0.01905f
C489 a_18628_1224# a_17308_1360# 0.02521f
C490 a_2908_29600# a_10108_29600# 1.00249f
C491 a_9308_6160# a_9494_4800# 0.03324f
C492 a_23428_54264# dout[4] 0.12915f
C493 a_33308_24800# a_43708_54400# 0.02596f
C494 dout[5] a_42508_33600# 1.03879f
C495 a_20908_46000# a_43828_54264# 0.18658f
C496 dout[7] a_47028_19064# 0.3859f
C497 comp_out_p dout[6] 3.13668f
C498 a_2228_20424# a_2108_20560# 3.2367f
C499 dout[2] dout[5] 0.11597f
C500 dout[1] dout[7] 0.1132f
C501 dout[0] comp_done 0.17797f
C502 dac_in[2] dac_in[6] 0.06041f
C503 dac_in[3] dac_in[5] 0.06149f
C504 sample_en a_34108_29600# 0.02298f
C505 a_23428_54264# a_24508_54400# 0.06024f
C506 a_10908_50400# a_9828_54264# 0.81014f
C507 a_4508_6160# a_2108_6160# 1.27786f
C508 comp_out_p a_36908_54400# 0.08922f
C509 a_44908_50400# a_46294_49200# 0.0129f
C510 done a_49708_29600# 0.02319f
C511 a_19708_41600# dout[3] 1.09035f
C512 dac_in[6] a_46294_53200# 0.03268f
C513 a_34108_41600# comp_out_p 0.09756f
C514 a_50908_37600# dout[6] 1.09035f
C515 sample_en a_53708_6800# 0.0461f
C516 rst_latch sample_en 15.1828f
C517 a_8108_6160# a_5708_6160# 0.46956f
C518 dac_in[5] a_35308_29600# 0.26776f
C519 a_33308_24800# a_43708_29600# 0.0362f
C520 dout[5] a_36908_50400# 1.0073f
C521 a_33308_6800# a_34508_6800# 1.00709f
C522 a_16228_10824# comp_out_p 0.01659f
C523 a_42508_37600# a_20908_46000# 0.0117f
C524 a_33308_12400# a_34508_12400# 1.00709f
C525 a_54908_1200# a_57308_1200# 0.04266f
C526 dac_in[0] dac_in[2] 0.06159f
C527 a_20908_46000# dac_in[4] 0.06756f
C528 a_50628_54264# comp_out_p 4.33487f
C529 a_15028_6024# a_18508_6160# 0.76262f
C530 a_2228_20424# a_3428_20424# 0.03237f
C531 a_47828_9464# a_49028_9464# 0.90778f
C532 a_23428_54264# dac_in[5] 0.13593f
C533 a_9708_50400# a_9828_54264# 0.99875f
C534 dout[5] dac_in[3] 0.06119f
C535 dout[6] dac_in[2] 0.06136f
C536 a_4508_6160# a_3428_6024# 0.04931f
C537 a_40508_1200# a_38108_1200# 0.04266f
C538 a_8108_6160# a_2228_6024# 0.34742f
C539 a_16628_54264# a_9828_54264# 25.736f
C540 comp_out_p a_37028_54264# 1.34672f
C541 done a_48508_29600# 0.01843f
C542 dout[3] a_9828_54264# 0.12675f
C543 a_4508_6160# a_5708_6160# 1.81793f
C544 done a_33308_19200# 15.2008f
C545 a_49708_37600# dout[6] 1.03879f
C546 a_35308_41600# comp_out_p 1.73849f
C547 a_43708_33600# a_43894_32400# 0.03264f
C548 a_5708_10960# comp_out_p 0.08566f
C549 dout[5] a_35308_29600# 1.51928f
C550 sample_en a_52508_6800# 0.01311f
C551 a_33308_24800# a_42508_29600# 0.05997f
C552 dout[4] a_51708_54400# 0.02711f
C553 a_11308_33600# a_12508_33600# 0.76551f
C554 a_33308_24800# a_47028_19064# 0.34115f
C555 a_33428_6664# a_34508_6800# 0.0395f
C556 a_33308_24800# dout[1] 0.24315f
C557 a_9828_54264# a_43828_54264# 0.13583f
C558 a_15028_10824# comp_out_p 0.07551f
C559 a_33428_12264# a_34508_12400# 0.0395f
C560 a_54908_1200# a_56108_1200# 1.00702f
C561 dout[0] a_3028_54264# 3.24219f
C562 a_50628_54264# dac_in[2] 0.12656f
C563 a_8108_6160# a_9494_4800# 0.05987f
C564 a_39428_3864# a_40628_3864# 0.90775f
C565 a_23308_54400# dac_in[3] 0.99858f
C566 a_23428_54264# dout[5] 0.12915f
C567 a_47028_19064# a_50908_41600# 0.02013f
C568 a_4508_6160# a_2228_6024# 0.24111f
C569 dac_in[6] a_16628_54264# 0.13602f
C570 a_19894_40400# a_18508_41600# 0.0129f
C571 dout[2] a_30228_54264# 0.12238f
C572 dout[3] dac_in[6] 0.05879f
C573 dout[2] dac_in[7] 0.06119f
C574 dout[4] dac_in[5] 0.06032f
C575 dac_in[2] a_37028_54264# 0.12915f
C576 a_48508_37600# dout[6] 0.03674f
C577 a_4508_6160# a_3308_6160# 0.2837f
C578 a_42508_33600# a_43894_32400# 0.0129f
C579 dac_in[4] a_9828_54264# 0.13507f
C580 a_10108_33600# a_12508_33600# 0.99858f
C581 a_52508_1200# a_53708_1200# 1.00702f
C582 a_51094_28400# a_47028_19064# 0.01077f
C583 a_33428_6664# a_33308_6800# 0.958f
C584 a_17708_54400# dout[2] 0.02132f
C585 sample_en a_43708_50400# 0.0333f
C586 dac_in[6] a_43828_54264# 3.47674f
C587 a_46294_53200# a_37028_54264# 0.02837f
C588 done a_50908_33600# 0.0288f
C589 a_33308_24800# a_41308_37600# 0.03101f
C590 a_33428_12264# a_33308_12400# 0.958f
C591 a_12294_53200# a_9828_54264# 0.01021f
C592 dac_in[0] a_16628_54264# 0.12915f
C593 dac_in[1] dout[2] 0.06119f
C594 dac_in[0] dout[3] 0.05879f
C595 a_43094_18000# comp_done 0.01847f
C596 a_46628_9464# a_47828_9464# 0.90775f
C597 a_23428_54264# a_23308_54400# 1.03325f
C598 a_47028_19064# a_49708_41600# 0.01969f
C599 a_20908_46000# a_9828_54264# 0.12835f
C600 dac_in[0] a_43828_54264# 0.12905f
C601 a_38108_50400# a_39494_49200# 0.0129f
C602 dout[6] a_16628_54264# 0.12915f
C603 dout[2] dout[7] 0.1132f
C604 dout[1] done 0.12157f
C605 a_43708_37600# dout[6] 1.09037f
C606 dout[0] sample_en 0.24993f
C607 dout[3] dout[6] 0.1151f
C608 dout[4] dout[5] 31.9942f
C609 done a_47028_19064# 8.32143f
C610 comp_out_p comp_done 16.2821f
C611 dac_in[3] dac_in[7] 0.06127f
C612 dac_in[4] dac_in[6] 0.06072f
C613 dac_in[3] a_30228_54264# 0.12915f
C614 a_50508_54400# a_43828_54264# 0.14384f
C615 a_51308_1200# a_53708_1200# 0.04266f
C616 a_10108_33600# a_11308_33600# 0.42399f
C617 sample_en a_38108_50400# 0.02811f
C618 done a_49708_33600# 0.02273f
C619 a_33308_24800# a_34108_37600# 0.23055f
C620 a_50628_54264# a_53094_49200# 0.03268f
C621 dout[6] a_43828_54264# 3.84193f
C622 dout[5] a_51708_54400# 0.01847f
C623 dac_in[7] a_35308_29600# 0.06119f
C624 a_30228_54264# a_35308_29600# 0.11997f
C625 a_33308_24800# a_43708_33600# 0.0362f
C626 a_34108_33600# comp_done 0.03012f
C627 rst_latch a_49708_29600# 0.037f
C628 a_42908_19200# comp_done 0.48597f
C629 dac_in[0] dac_in[4] 0.06127f
C630 dac_in[1] dac_in[3] 0.06159f
C631 a_50628_54264# a_16628_54264# 0.1341f
C632 a_50628_54264# dout[3] 0.12065f
C633 a_20908_46000# dac_in[6] 0.06475f
C634 a_3428_6024# a_2108_6160# 0.02521f
C635 a_47028_19064# a_48508_41600# 0.02674f
C636 a_20908_6160# a_15028_6024# 0.34742f
C637 comp_done a_4108_46000# 0.07784f
C638 a_5708_6160# a_2108_6160# 0.4841f
C639 a_42508_37600# dout[6] 1.03879f
C640 a_23428_54264# dac_in[7] 0.13602f
C641 a_23308_54400# a_24508_54400# 0.42392f
C642 a_50628_54264# a_43828_54264# 26.0744f
C643 a_23428_54264# a_30228_54264# 25.736f
C644 dac_in[1] a_35308_29600# 0.0545f
C645 comp_done dac_in[2] 0.06756f
C646 dout[7] dac_in[3] 0.06136f
C647 a_16628_54264# a_37028_54264# 0.1363f
C648 dout[5] dac_in[5] 0.12746f
C649 dout[6] dac_in[4] 0.06119f
C650 a_38908_41600# a_20908_46000# 0.02366f
C651 dout[3] a_37028_54264# 0.12238f
C652 a_41308_29600# a_43708_29600# 0.99858f
C653 a_2908_33600# a_11308_33600# 0.04546f
C654 done a_48508_33600# 0.01843f
C655 a_33308_19200# a_34108_29600# 0.01826f
C656 a_49708_37600# comp_done 0.0193f
C657 a_20908_46000# dac_in[0] 0.06079f
C658 a_33308_24800# a_42508_33600# 0.05968f
C659 dout[7] a_35308_29600# 0.11817f
C660 rst_latch a_48508_29600# 0.03785f
C661 a_43828_54264# a_37028_54264# 26.1538f
C662 a_38108_54400# a_36908_54400# 0.42392f
C663 a_33308_24800# dout[2] 0.24682f
C664 rst_latch a_33308_19200# 0.13526f
C665 a_35494_32400# a_35308_29600# 0.01905f
C666 a_23428_54264# dac_in[1] 0.12915f
C667 comp_done a_2908_50400# 0.01827f
C668 a_45428_9464# a_46628_9464# 0.90778f
C669 a_2228_6024# a_2108_6160# 3.2367f
C670 comp_done a_2908_46000# 0.96866f
C671 comp_out_p a_3028_54264# 6.70725f
C672 a_20908_46000# dout[6] 0.2267f
C673 a_17308_6160# a_15028_6024# 0.24111f
C674 a_12694_40400# a_12508_41600# 0.03264f
C675 a_50628_54264# dac_in[4] 0.12656f
C676 a_33308_24800# a_36908_50400# 0.01467f
C677 a_47828_15064# a_46628_15064# 0.90775f
C678 a_3308_6160# a_2108_6160# 1.39926f
C679 done a_34108_37600# 0.02619f
C680 a_23428_54264# dout[7] 0.12915f
C681 a_41308_29600# a_42508_29600# 0.42399f
C682 a_2908_33600# a_10108_33600# 1.00249f
C683 dout[4] a_30228_54264# 3.52758f
C684 a_4508_10960# comp_out_p 0.02401f
C685 dout[4] dac_in[7] 0.06317f
C686 a_48508_37600# comp_done 0.03074f
C687 dac_in[4] a_37028_54264# 0.12915f
C688 dout[0] a_5494_49200# 0.012f
C689 comp_out_p a_50508_50400# 0.07218f
C690 dac_in[6] a_9828_54264# 0.13525f
C691 a_38108_54400# a_37028_54264# 0.04143f
C692 a_50628_54264# a_20908_46000# 0.12595f
C693 dac_in[7] a_51708_54400# 0.80903f
C694 comp_out_p a_2908_54400# 0.0238f
C695 a_33308_24800# dac_in[3] 0.13513f
C696 a_50908_41600# a_51094_40400# 0.03264f
C697 a_2228_6024# a_3428_6024# 0.03237f
C698 a_41308_33600# sample_en 0.02104f
C699 a_14908_6160# a_15028_6024# 3.2367f
C700 dac_in[1] dout[4] 0.06119f
C701 a_12694_40400# a_11308_41600# 0.0129f
C702 dac_in[2] a_3028_54264# 0.13507f
C703 a_20908_46000# a_37028_54264# 0.1883f
C704 dac_in[0] a_9828_54264# 0.38398f
C705 a_33308_24800# a_35308_29600# 3.57498f
C706 a_3308_6160# a_3428_6024# 1.05947f
C707 a_5708_6160# a_2228_6024# 0.76262f
C708 a_17308_15760# a_16108_15760# 0.2837f
C709 a_17308_41600# dout[0] 0.0327f
C710 a_16108_10960# a_18508_10960# 0.06606f
C711 comp_done a_16628_54264# 0.12157f
C712 a_34108_29600# a_42508_29600# 0.04546f
C713 a_2108_10960# comp_out_p 0.03507f
C714 a_42294_23600# a_40908_24800# 0.0129f
C715 a_3308_6160# a_5708_6160# 0.06606f
C716 dout[3] comp_done 0.12835f
C717 comp_out_p sample_en 2.40575f
C718 dout[4] dout[7] 0.2579f
C719 dout[2] done 0.12341f
C720 dac_in[5] dac_in[7] 0.06159f
C721 dac_in[5] a_30228_54264# 0.13593f
C722 dout[6] a_9828_54264# 0.12675f
C723 a_52508_1200# a_54908_1200# 0.04266f
C724 a_33428_3864# a_33308_4000# 0.90385f
C725 a_18508_10960# a_14908_10960# 0.4841f
C726 rst_latch a_42508_29600# 0.01008f
C727 a_3028_54264# a_2908_50400# 0.99858f
C728 rst_latch a_47028_19064# 0.18755f
C729 a_32694_53200# dac_in[4] 0.03268f
C730 rst_latch dout[1] 0.12157f
C731 comp_done a_43828_54264# 1.40972f
C732 a_5494_53200# a_4108_54400# 0.0129f
C733 comp_out_p a_9708_54400# 0.07139f
C734 dout[7] a_51708_54400# 0.0225f
C735 a_23428_54264# a_33308_24800# 0.26545f
C736 a_44228_9464# a_45428_9464# 0.90775f
C737 a_51094_36400# dout[5] 0.0134f
C738 sample_en a_55028_9464# 0.01137f
C739 rst_latch a_49708_33600# 0.03145f
C740 a_34108_33600# sample_en 0.02298f
C741 a_49708_41600# a_51094_40400# 0.0129f
C742 a_18508_6160# a_16108_6160# 0.06606f
C743 a_44228_3864# a_45428_3864# 0.90775f
C744 a_16228_6024# a_15028_6024# 0.03237f
C745 a_41308_41600# dout[6] 0.05122f
C746 a_2108_15760# a_5708_15760# 0.4841f
C747 dac_in[1] dac_in[5] 0.06117f
C748 dac_in[0] dac_in[6] 0.06032f
C749 a_3308_6160# a_2228_6024# 0.25574f
C750 a_14908_15760# a_16108_15760# 1.39926f
C751 a_4108_50400# comp_done 0.02742f
C752 a_34108_41600# a_41308_41600# 1.00249f
C753 a_3428_10824# comp_out_p 0.02118f
C754 a_50628_54264# a_9828_54264# 0.1341f
C755 a_2108_15760# a_33308_19200# 0.02806f
C756 done dac_in[3] 0.06756f
C757 comp_done dac_in[4] 0.21082f
C758 dout[7] dac_in[5] 0.06109f
C759 dout[6] dac_in[6] 0.27761f
C760 dout[5] dac_in[7] 0.06493f
C761 sample_en dac_in[2] 0.13513f
C762 a_16108_10960# a_14908_10960# 1.39926f
C763 dout[0] a_33308_19200# 0.12734f
C764 a_24694_0# a_24508_1360# 0.03324f
C765 dac_in[1] a_10908_54400# 0.80903f
C766 dout[5] a_30228_54264# 0.12915f
C767 a_9828_54264# a_37028_54264# 0.1361f
C768 sample_en a_53828_9464# 0.05234f
C769 rst_latch a_48508_33600# 0.02515f
C770 done a_35308_29600# 0.21643f
C771 a_59828_15064# a_61028_15064# 0.90066f
C772 a_22294_4800# a_22108_6160# 0.03324f
C773 a_33308_24800# dout[4] 0.44648f
C774 a_2108_15760# a_3308_15760# 1.39926f
C775 a_3028_54264# a_16628_54264# 0.13674f
C776 dac_in[1] dout[5] 0.06136f
C777 a_23428_15624# a_22108_15760# 0.26027f
C778 a_16228_15624# a_16108_15760# 1.05947f
C779 dac_in[0] dout[6] 0.05959f
C780 a_12508_33600# a_12694_32400# 0.03264f
C781 a_20908_46000# comp_done 0.13245f
C782 dout[3] a_3028_54264# 0.12915f
C783 a_34108_41600# a_38908_41600# 0.33005f
C784 a_50628_54264# dac_in[6] 0.30097f
C785 a_50508_54400# dout[6] 0.02432f
C786 a_2228_10824# comp_out_p 0.04802f
C787 comp_out_p a_16108_15760# 0.02485f
C788 dout[4] a_50908_41600# 0.02564f
C789 a_18508_41600# comp_out_p 0.0257f
C790 a_23428_54264# done 0.13273f
C791 a_18508_10960# a_15028_10824# 0.76262f
C792 a_16108_10960# a_16228_10824# 1.05947f
C793 a_3028_54264# a_43828_54264# 0.13583f
C794 dout[5] dout[7] 0.26362f
C795 a_25894_49200# a_24508_50400# 0.0129f
C796 a_46294_49200# a_43828_54264# 0.03268f
C797 dac_in[6] a_37028_54264# 0.17989f
C798 sample_en a_52628_9464# 0.01026f
C799 a_35494_36400# comp_out_p 0.08221f
C800 a_16228_10824# a_14908_10960# 0.02521f
C801 a_43028_3864# a_44228_3864# 0.90778f
C802 a_50628_54264# dac_in[0] 0.12656f
C803 a_43028_9464# a_44228_9464# 0.90778f
C804 a_2228_15624# a_5708_15760# 0.76262f
C805 a_3428_15624# a_3308_15760# 1.05947f
C806 a_4108_50400# a_3028_54264# 0.80903f
C807 a_33308_24800# dac_in[5] 0.28294f
C808 a_50628_54264# a_50508_54400# 1.00722f
C809 a_11308_33600# a_12694_32400# 0.0129f
C810 a_20908_15760# a_22108_15760# 2.73702f
C811 a_59828_3864# a_61028_3864# 0.90066f
C812 a_24508_15760# a_23428_15624# 0.04888f
C813 a_35308_41600# a_38908_41600# 1.36391f
C814 dac_in[0] a_37028_54264# 0.12915f
C815 dac_in[4] a_3028_54264# 0.13515f
C816 a_35894_23600# a_35708_24800# 0.042f
C817 a_55028_9464# a_56228_9464# 0.90778f
C818 a_50628_54264# dout[6] 0.19628f
C819 a_42294_23600# a_33308_24800# 0.01226f
C820 dout[4] a_49708_41600# 0.02765f
C821 a_2228_15624# a_33308_19200# 0.02937f
C822 a_17308_41600# comp_out_p 0.03038f
C823 a_16108_10960# a_15028_10824# 0.25574f
C824 a_24694_0# a_23308_1360# 0.05987f
C825 dout[0] dout[1] 31.7378f
C826 dout[0] a_47028_19064# 0.12835f
C827 sample_en a_16628_54264# 0.24993f
C828 dout[4] done 0.2228f
C829 comp_out_p a_51708_50400# 0.98755f
C830 a_43708_37600# sample_en 0.0288f
C831 dout[3] sample_en 0.2567f
C832 dout[6] a_37028_54264# 0.12921f
C833 dac_in[7] a_30228_54264# 0.13593f
C834 a_15028_10824# a_14908_10960# 3.2367f
C835 a_19708_1360# a_20908_1360# 1.81785f
C836 comp_done a_9828_54264# 0.12835f
C837 a_39708_24800# a_40908_24800# 0.42392f
C838 a_24508_6160# a_22108_6160# 1.03812f
C839 a_59708_6800# a_60908_6800# 0.96154f
C840 rst_latch dout[2] 0.12341f
C841 a_37028_54264# a_36908_54400# 1.0073f
C842 a_2228_15624# a_3308_15760# 0.25574f
C843 a_20908_46000# a_3028_54264# 0.12157f
C844 sample_en a_43828_54264# 0.71537f
C845 a_33308_24800# dout[5] 3.49851f
C846 a_14908_6160# a_35308_29600# 0.02004f
C847 dout[1] a_12294_49200# 0.01043f
C848 a_24508_15760# a_20908_15760# 0.04749f
C849 a_35308_41600# a_34108_41600# 0.87222f
C850 a_16508_54400# dout[1] 0.0185f
C851 dac_in[1] dac_in[7] 0.06119f
C852 a_35894_23600# a_33308_24800# 0.01847f
C853 comp_out_p a_5708_15760# 0.08566f
C854 dac_in[1] a_30228_54264# 0.12915f
C855 a_12508_41600# comp_out_p 0.01824f
C856 a_50628_54264# a_37028_54264# 0.1349f
C857 a_18508_41600# a_7708_41600# 0.04546f
C858 dout[5] a_50908_41600# 0.02873f
C859 a_42508_37600# sample_en 0.0229f
C860 a_15028_10824# a_16228_10824# 0.03237f
C861 a_19708_1360# a_18508_1360# 0.2837f
C862 done dac_in[5] 0.06079f
C863 comp_done dac_in[6] 0.13166f
C864 dout[7] dac_in[7] 0.14152f
C865 sample_en dac_in[4] 0.13513f
C866 comp_out_p a_33308_19200# 1.18496f
C867 dout[7] a_30228_54264# 0.12915f
C868 a_43894_28400# a_43708_29600# 0.03264f
C869 a_41828_3864# a_43028_3864# 0.90775f
C870 a_41828_9464# a_43028_9464# 0.90775f
C871 sample_en a_38108_54400# 0.02811f
C872 rst_latch dac_in[3] 0.06756f
C873 a_16228_6024# a_35308_29600# 0.02431f
C874 a_18508_1360# a_20908_1360# 0.06606f
C875 a_14908_46000# a_35308_29600# 0.01548f
C876 a_43708_37600# a_43894_36400# 0.03264f
C877 a_9308_20560# a_9494_19200# 0.03324f
C878 a_17308_6160# a_16108_6160# 0.2837f
C879 a_34108_29600# a_35308_29600# 1.58673f
C880 a_58628_3864# a_59828_3864# 0.90775f
C881 a_38908_41600# comp_done 0.01176f
C882 a_18508_15760# a_20908_15760# 0.46956f
C883 a_34108_33600# a_33308_19200# 0.01826f
C884 dac_in[1] dout[7] 0.06199f
C885 comp_out_p a_3308_15760# 0.02746f
C886 dac_in[0] comp_done 0.06272f
C887 rst_latch a_35308_29600# 0.19741f
C888 a_11708_10960# a_9308_10960# 1.03812f
C889 a_11308_41600# comp_out_p 0.02874f
C890 a_20908_46000# sample_en 15.4127f
C891 a_17308_41600# a_7708_41600# 1.00186f
C892 a_3028_54264# a_9828_54264# 26.121f
C893 dout[5] a_49708_41600# 0.01521f
C894 a_51308_1200# a_52508_1200# 1.00762f
C895 a_44908_54400# a_46294_53200# 0.0129f
C896 a_4294_36400# comp_out_p 0.08144f
C897 a_18508_41600# dout[3] 1.03879f
C898 dout[6] comp_done 0.73861f
C899 a_55028_3864# a_56228_3864# 0.90778f
C900 dout[5] done 0.21603f
C901 a_33308_24800# a_40908_24800# 0.03499f
C902 a_43894_28400# a_42508_29600# 0.0129f
C903 dout[4] a_41308_29600# 0.03674f
C904 dac_in[2] a_33308_19200# 0.06756f
C905 a_23428_54264# rst_latch 0.13273f
C906 a_42508_37600# a_43894_36400# 0.0129f
C907 a_14908_6160# a_16108_6160# 1.39926f
C908 a_34108_41600# comp_done 0.03041f
C909 a_20908_15760# a_15028_15624# 0.34742f
C910 a_18508_15760# a_17308_15760# 1.81793f
C911 a_17308_46000# dout[1] 0.0278f
C912 a_33308_24800# dac_in[7] 0.13513f
C913 a_33308_24800# a_30228_54264# 0.29834f
C914 a_33308_24800# a_43894_32400# 0.01137f
C915 a_53094_49200# a_51708_50400# 0.0129f
C916 a_10108_41600# comp_out_p 0.12837f
C917 a_11708_10960# a_10628_10824# 0.04888f
C918 a_44908_50400# a_35308_29600# 0.02182f
C919 dac_in[6] a_3028_54264# 0.13547f
C920 a_50108_1200# a_52508_1200# 0.04266f
C921 dout[7] a_42508_41600# 1.03879f
C922 a_50628_54264# comp_done 0.13009f
C923 a_20908_6160# a_22294_4800# 0.05987f
C924 a_17308_41600# dout[3] 0.03674f
C925 a_4108_50400# a_5494_49200# 0.0129f
C926 comp_out_p a_12508_37600# 0.01615f
C927 dout[1] comp_out_p 3.84509f
C928 a_40628_3864# a_41828_3864# 0.90778f
C929 comp_out_p a_47028_19064# 16.7649f
C930 dout[0] dout[2] 0.60334f
C931 a_33308_24800# dac_in[1] 0.12157f
C932 a_33308_24800# a_39708_24800# 0.03191f
C933 dout[4] a_34108_29600# 0.09997f
C934 a_40628_9464# a_41828_9464# 0.90778f
C935 comp_done a_37028_54264# 0.12157f
C936 a_16228_6024# a_16108_6160# 1.05947f
C937 a_23428_6024# a_22108_6160# 0.26027f
C938 a_3308_20560# a_5708_20560# 0.06606f
C939 a_8108_20560# a_9494_19200# 0.05987f
C940 comp_out_p a_49708_33600# 0.04546f
C941 a_9308_20560# a_11708_20560# 1.00563f
C942 sample_en a_9828_54264# 0.2567f
C943 a_17308_15760# a_15028_15624# 0.24111f
C944 a_18508_15760# a_14908_15760# 0.4841f
C945 a_50908_37600# a_47028_19064# 0.02013f
C946 a_57428_3864# a_58628_3864# 0.90778f
C947 a_60908_6800# a_58508_6800# 0.0395f
C948 dac_in[0] a_3028_54264# 3.04971f
C949 rst_latch dout[4] 0.37416f
C950 comp_out_p a_24508_50400# 1.01975f
C951 a_33308_24800# dout[7] 0.43817f
C952 a_9828_54264# a_9708_54400# 1.01064f
C953 a_42908_19200# a_47028_19064# 0.01361f
C954 a_15028_6024# comp_out_p 0.08891f
C955 a_11708_10960# a_8108_10960# 0.04749f
C956 a_41308_41600# sample_en 0.02104f
C957 a_38108_50400# a_36908_50400# 0.42392f
C958 a_23428_54264# a_25894_49200# 0.03268f
C959 a_43708_50400# a_35308_29600# 0.02621f
C960 a_16508_54400# dout[2] 0.05201f
C961 a_16508_50400# dout[1] 0.0185f
C962 a_50108_1200# a_51308_1200# 1.00702f
C963 a_23428_6024# a_24508_6160# 0.04888f
C964 dout[6] a_3028_54264# 0.12915f
C965 a_12508_41600# dout[3] 1.09037f
C966 comp_out_p a_11308_37600# 0.01774f
C967 a_33308_24800# a_35708_24800# 0.48597f
C968 a_44908_54400# a_43828_54264# 0.04423f
C969 comp_out_p a_41308_37600# 0.06728f
C970 dout[0] dac_in[3] 0.06119f
C971 dac_in[2] a_47028_19064# 0.06756f
C972 dout[7] a_50908_41600# 1.09035f
C973 dout[1] dac_in[2] 0.06394f
C974 a_2908_41600# a_33308_19200# 0.01463f
C975 dac_in[0] a_2908_54400# 0.99858f
C976 a_23308_1360# a_20908_1360# 0.46956f
C977 done dac_in[7] 0.06756f
C978 a_20908_6160# a_22108_6160# 2.73702f
C979 sample_en dac_in[6] 1.29374f
C980 a_10628_20424# a_11708_20560# 0.04542f
C981 comp_out_p a_48508_33600# 1.00186f
C982 a_33308_19200# a_16628_54264# 0.12157f
C983 dout[6] a_50508_50400# 0.02568f
C984 a_49708_37600# a_47028_19064# 0.01969f
C985 dout[3] a_33308_19200# 0.12835f
C986 done a_30228_54264# 0.27292f
C987 a_33308_24800# a_42508_41600# 0.05964f
C988 a_59708_6800# a_58508_6800# 1.0077f
C989 a_14908_15760# a_15028_15624# 3.2367f
C990 a_18508_41600# a_19708_41600# 0.76551f
C991 a_19708_33600# dout[1] 1.09035f
C992 rst_latch dac_in[5] 0.06079f
C993 dout[0] a_35308_29600# 1.10468f
C994 a_50628_54264# a_3028_54264# 0.1341f
C995 a_18508_15760# comp_out_p 0.05074f
C996 a_33308_19200# a_43828_54264# 0.12749f
C997 a_5708_10960# a_8108_10960# 0.46956f
C998 a_18508_46000# dout[2] 0.04155f
C999 a_38908_41600# sample_en 0.04374f
C1000 a_38108_50400# a_35308_29600# 0.98945f
C1001 a_41308_33600# a_43708_33600# 0.99858f
C1002 a_11308_41600# a_2908_41600# 0.04546f
C1003 dout[0] a_17308_37600# 0.0327f
C1004 a_48908_1200# a_51308_1200# 0.04266f
C1005 a_20908_6160# a_24508_6160# 0.04749f
C1006 a_42294_23600# rst_latch 0.03268f
C1007 dac_in[1] done 0.06079f
C1008 dac_in[0] sample_en 0.12157f
C1009 a_10628_10824# a_9308_10960# 0.26027f
C1010 a_11308_41600# dout[3] 1.03879f
C1011 comp_out_p a_5708_20560# 0.08566f
C1012 comp_out_p a_10108_37600# 0.10239f
C1013 a_3028_54264# a_37028_54264# 0.13593f
C1014 a_43708_54400# a_43828_54264# 1.00906f
C1015 comp_out_p a_34108_37600# 1.68315f
C1016 a_50628_54264# a_50508_50400# 0.99875f
C1017 a_10908_50400# dout[1] 0.06662f
C1018 a_23428_54264# dout[0] 0.12238f
C1019 a_39428_9464# a_40628_9464# 0.90775f
C1020 a_7708_41600# dout[1] 0.01064f
C1021 dout[7] a_49708_41600# 1.03879f
C1022 a_9308_15760# a_2228_15624# 0.07546f
C1023 a_8108_15760# a_2108_15760# 0.29742f
C1024 a_25828_1224# a_24508_1360# 0.26014f
C1025 a_16508_54400# a_35308_29600# 0.0208f
C1026 a_8108_20560# a_11708_20560# 0.03504f
C1027 a_48508_37600# a_47028_19064# 0.02674f
C1028 dout[6] sample_en 0.56584f
C1029 a_59708_6800# a_57308_6800# 0.04266f
C1030 dout[7] done 0.30953f
C1031 a_57428_15064# a_58628_15064# 0.90778f
C1032 a_56228_3864# a_57428_3864# 0.90775f
C1033 a_16228_15624# a_15028_15624# 0.03237f
C1034 a_17308_41600# a_19708_41600# 0.99858f
C1035 dac_in[4] a_33308_19200# 0.10563f
C1036 a_18508_33600# dout[1] 1.03879f
C1037 rst_latch dout[5] 0.3499f
C1038 a_20908_46000# a_44908_54400# 0.01852f
C1039 a_15028_15624# comp_out_p 0.07551f
C1040 a_5708_10960# a_4508_10960# 1.81793f
C1041 a_34108_41600# sample_en 0.02377f
C1042 a_17308_46000# dout[2] 0.02929f
C1043 a_10108_41600# a_2908_41600# 1.00249f
C1044 a_41308_33600# a_42508_33600# 0.42399f
C1045 a_48908_1200# a_50108_1200# 1.00762f
C1046 a_20908_6160# a_18508_6160# 0.46956f
C1047 a_35708_24800# done 0.01607f
C1048 a_2908_29600# a_33308_19200# 0.01463f
C1049 a_9308_10960# a_8108_10960# 2.73702f
C1050 comp_out_p a_2908_37600# 1.90103f
C1051 a_10108_41600# dout[3] 0.03674f
C1052 a_12508_33600# dout[0] 0.03546f
C1053 comp_out_p a_19708_37600# 0.01936f
C1054 a_9708_50400# dout[1] 1.02698f
C1055 a_50628_54264# sample_en 0.35747f
C1056 a_20908_46000# a_33308_19200# 0.13245f
C1057 dout[7] a_48508_41600# 0.03674f
C1058 a_39494_49200# a_37028_54264# 0.03268f
C1059 a_23308_1360# a_24508_1360# 2.73689f
C1060 a_4508_15760# a_2108_15760# 1.27786f
C1061 a_47028_19064# a_16628_54264# 0.12835f
C1062 a_8108_20560# a_5708_20560# 0.46956f
C1063 dout[1] a_16628_54264# 0.15989f
C1064 dout[3] a_47028_19064# 0.12835f
C1065 dout[0] dout[4] 0.12255f
C1066 a_3308_20560# a_2108_20560# 1.39926f
C1067 dout[1] dout[3] 0.23905f
C1068 comp_out_p dout[2] 2.80026f
C1069 a_44108_1200# a_45308_1200# 1.00762f
C1070 a_17308_33600# dout[1] 0.03674f
C1071 sample_en a_37028_54264# 1.81629f
C1072 a_20908_46000# a_43708_54400# 0.0181f
C1073 a_14908_15760# a_35308_29600# 0.01927f
C1074 a_5708_10960# a_2108_10960# 0.4841f
C1075 a_47028_19064# a_43828_54264# 0.40085f
C1076 dout[1] a_43828_54264# 0.1156f
C1077 a_34108_33600# a_42508_33600# 0.04546f
C1078 dout[3] a_24508_50400# 0.0506f
C1079 a_47708_1200# a_50108_1200# 0.04266f
C1080 comp_out_p a_36908_50400# 0.09444f
C1081 a_33308_24800# done 1.24959f
C1082 a_17308_6160# a_18508_6160# 1.81793f
C1083 a_10628_10824# a_8108_10960# 0.08029f
C1084 a_11308_33600# dout[0] 0.04175f
C1085 a_16508_50400# dout[2] 1.06176f
C1086 comp_out_p a_18508_37600# 0.07684f
C1087 a_20908_46000# a_43708_29600# 0.0312f
C1088 dout[7] a_43708_41600# 1.09037f
C1089 a_38228_9464# a_39428_9464# 0.90778f
C1090 comp_done a_3028_54264# 0.1799f
C1091 a_8108_15760# a_2228_15624# 0.34742f
C1092 a_4508_15760# a_3428_15624# 0.04931f
C1093 a_49708_41600# a_50908_41600# 0.76551f
C1094 a_23308_1360# a_25828_1224# 0.08029f
C1095 a_4508_20560# a_5708_20560# 1.81793f
C1096 a_3308_20560# a_3428_20424# 1.05947f
C1097 a_41308_33600# a_35308_29600# 0.07647f
C1098 a_56228_15064# a_57428_15064# 0.90775f
C1099 a_43894_40400# a_42508_41600# 0.0129f
C1100 a_33428_9464# a_33308_9600# 0.90385f
C1101 a_40908_24800# rst_latch 0.80903f
C1102 a_43708_37600# a_41308_37600# 0.99858f
C1103 comp_out_p dac_in[3] 0.38246f
C1104 dout[0] dac_in[5] 0.06032f
C1105 dac_in[4] a_47028_19064# 0.06756f
C1106 done a_50908_41600# 0.0288f
C1107 dout[2] dac_in[2] 0.06921f
C1108 dout[1] dac_in[4] 0.06119f
C1109 a_22108_15760# a_22294_14400# 0.03324f
C1110 a_42908_1200# a_45308_1200# 0.04266f
C1111 a_23308_50400# a_24508_50400# 0.42392f
C1112 a_16228_15624# a_35308_29600# 0.01824f
C1113 a_4508_6160# comp_out_p 0.02941f
C1114 dout[5] a_43708_50400# 0.01429f
C1115 a_33308_19200# a_9828_54264# 0.12835f
C1116 rst_latch a_30228_54264# 0.12595f
C1117 rst_latch dac_in[7] 0.06756f
C1118 a_47708_1200# a_48908_1200# 1.00702f
C1119 comp_out_p a_35308_29600# 46.619f
C1120 a_14908_6160# a_18508_6160# 0.4841f
C1121 a_42508_41600# a_43708_41600# 0.76551f
C1122 a_35494_28400# a_35308_29600# 0.04392f
C1123 comp_done a_2908_54400# 0.01827f
C1124 a_10108_33600# dout[0] 0.05122f
C1125 a_20908_6160# a_23428_6024# 0.08029f
C1126 a_17708_50400# dout[1] 0.01884f
C1127 a_51094_32400# a_50908_33600# 0.03264f
C1128 a_20908_46000# a_42508_29600# 0.0117f
C1129 a_43894_40400# a_33308_24800# 0.01137f
C1130 comp_out_p a_17308_37600# 1.03344f
C1131 a_2108_20560# comp_out_p 0.03507f
C1132 a_20908_46000# a_47028_19064# 0.12771f
C1133 a_20908_46000# dout[1] 0.12157f
C1134 a_39308_1200# a_41708_1200# 0.04266f
C1135 a_4508_15760# a_2228_15624# 0.24111f
C1136 a_16108_46000# a_35308_29600# 0.04535f
C1137 dac_in[6] a_44908_54400# 0.80903f
C1138 a_48508_41600# a_50908_41600# 0.99858f
C1139 a_34108_33600# a_35308_29600# 0.11586f
C1140 a_3308_20560# a_2228_20424# 0.25574f
C1141 a_55028_3864# a_53828_3864# 0.90775f
C1142 a_39708_24800# rst_latch 0.99858f
C1143 dac_in[1] rst_latch 0.06079f
C1144 a_42508_37600# a_41308_37600# 0.42399f
C1145 done a_49708_41600# 0.02273f
C1146 a_23428_54264# comp_out_p 2.2938f
C1147 a_7708_41600# dout[2] 0.01285f
C1148 a_42908_1200# a_44108_1200# 1.00702f
C1149 dout[0] dout[5] 0.1156f
C1150 a_16508_50400# a_35308_29600# 0.0208f
C1151 dac_in[2] dac_in[3] 25.6599f
C1152 a_45308_6800# a_46508_6800# 1.00702f
C1153 comp_done sample_en 15.1267f
C1154 a_33308_24800# a_43708_41600# 0.0362f
C1155 dout[6] a_51708_50400# 0.01837f
C1156 a_5708_10960# a_2228_10824# 0.76262f
C1157 a_57308_6800# a_58508_6800# 1.00702f
C1158 dout[5] a_38108_50400# 0.04143f
C1159 dac_in[6] a_33308_19200# 0.06079f
C1160 a_46508_1200# a_48908_1200# 0.04266f
C1161 rst_latch dout[7] 0.36306f
C1162 dac_in[2] a_35308_29600# 0.06119f
C1163 a_33308_24800# a_41308_29600# 0.03611f
C1164 a_51094_32400# a_49708_33600# 0.0129f
C1165 a_41308_33600# dout[4] 0.05122f
C1166 a_3428_20424# comp_out_p 0.02118f
C1167 a_48508_41600# a_49708_41600# 0.42399f
C1168 dac_in[6] a_43708_54400# 0.99858f
C1169 a_39308_1200# a_40508_1200# 1.00762f
C1170 a_12508_33600# comp_out_p 0.01615f
C1171 a_9308_20560# a_2228_20424# 0.07546f
C1172 a_55028_15064# a_56228_15064# 0.90778f
C1173 a_8108_20560# a_2108_20560# 0.29742f
C1174 a_42508_37600# a_34108_37600# 0.04546f
C1175 a_48908_1200# sample_en 0.05155f
C1176 dac_in[0] a_33308_19200# 0.06079f
C1177 done a_48508_41600# 0.01843f
C1178 a_50628_54264# a_51708_50400# 0.81019f
C1179 a_41708_1200# a_44108_1200# 0.04266f
C1180 a_44228_15064# a_44108_15200# 0.8814f
C1181 dout[2] a_16628_54264# 3.42041f
C1182 a_23428_54264# dac_in[2] 0.12915f
C1183 comp_out_p dout[4] 0.91562f
C1184 dout[2] dout[3] 30.7048f
C1185 a_4508_15760# comp_out_p 0.02401f
C1186 a_56108_6800# a_58508_6800# 0.04266f
C1187 a_44108_6800# a_46508_6800# 0.04266f
C1188 a_3028_54264# a_2908_54400# 1.01296f
C1189 comp_out_p a_24508_54400# 0.02782f
C1190 a_47028_19064# a_9828_54264# 0.12835f
C1191 a_46508_1200# a_47708_1200# 1.00762f
C1192 dout[1] a_9828_54264# 3.41259f
C1193 comp_out_p a_16108_6160# 0.02558f
C1194 dout[6] a_33308_19200# 0.12157f
C1195 a_2108_10960# a_8108_10960# 0.29742f
C1196 a_9308_10960# a_2228_10824# 0.07546f
C1197 dout[2] a_43828_54264# 0.1156f
C1198 a_50908_37600# dout[4] 0.02564f
C1199 a_7708_41600# a_35308_29600# 0.03152f
C1200 a_59828_9464# a_61028_9464# 0.90066f
C1201 a_2228_20424# comp_out_p 0.04802f
C1202 a_33308_24800# a_34108_29600# 0.23506f
C1203 a_34108_41600# a_33308_19200# 0.01826f
C1204 a_4508_20560# a_2108_20560# 1.27786f
C1205 a_33308_24800# rst_latch 0.47253f
C1206 a_20908_46000# a_43708_33600# 0.03128f
C1207 a_44908_54400# a_37028_54264# 0.0446f
C1208 sample_en a_3028_54264# 0.24315f
C1209 a_41708_1200# a_42908_1200# 1.00762f
C1210 a_50628_54264# a_33308_19200# 0.12595f
C1211 a_51428_15064# a_52628_15064# 0.90775f
C1212 comp_out_p a_2108_6160# 0.03813f
C1213 a_56108_6800# a_57308_6800# 1.00762f
C1214 dac_in[3] a_16628_54264# 0.13593f
C1215 a_44108_6800# a_45308_6800# 1.00762f
C1216 comp_out_p dac_in[5] 0.60279f
C1217 dac_in[6] a_47028_19064# 0.28434f
C1218 dout[0] dac_in[7] 0.06119f
C1219 dout[3] dac_in[3] 0.06119f
C1220 dout[2] dac_in[4] 0.06119f
C1221 dout[0] a_30228_54264# 0.12238f
C1222 dout[1] dac_in[6] 0.05879f
C1223 dout[4] dac_in[2] 0.06119f
C1224 a_60908_1200# a_59708_1200# 0.96154f
C1225 a_3028_54264# a_9708_54400# 0.03856f
C1226 a_2108_10960# a_4508_10960# 1.27786f
C1227 a_49708_37600# dout[4] 0.02765f
C1228 a_52628_15064# a_53828_15064# 0.90778f
C1229 a_16628_54264# a_35308_29600# 0.16241f
C1230 a_33308_19200# a_37028_54264# 0.12595f
C1231 a_17708_54400# dout[0] 0.03827f
C1232 dac_in[3] a_43828_54264# 0.12905f
C1233 a_14908_6160# a_20908_6160# 0.29742f
C1234 dout[3] a_35308_29600# 0.17775f
C1235 a_38908_41600# a_47028_19064# 0.15854f
C1236 comp_out_p a_10908_54400# 0.07763f
C1237 a_8108_20560# a_2228_20424# 0.34742f
C1238 a_53828_15064# a_55028_15064# 0.90775f
C1239 a_4508_20560# a_3428_20424# 0.04931f
C1240 a_10108_33600# comp_out_p 0.07854f
C1241 a_41308_33600# dout[5] 0.03674f
C1242 dac_in[0] a_47028_19064# 0.06079f
C1243 a_17708_50400# dout[2] 0.06426f
C1244 dac_in[1] dout[0] 0.06119f
C1245 dac_in[0] dout[1] 2.36997f
C1246 a_20908_46000# a_42508_33600# 0.0117f
C1247 a_43708_54400# a_37028_54264# 0.0654f
C1248 a_20908_46000# dout[2] 0.12341f
C1249 a_43828_54264# a_35308_29600# 0.17964f
C1250 a_40508_1200# a_42908_1200# 0.04266f
C1251 a_50508_54400# a_47028_19064# 0.02304f
C1252 comp_out_p a_3428_6024# 0.02123f
C1253 a_43894_40400# a_43708_41600# 0.03264f
C1254 a_42908_6800# a_45308_6800# 0.04266f
C1255 a_54908_6800# a_57308_6800# 0.04266f
C1256 a_23428_54264# a_16628_54264# 25.736f
C1257 a_23428_54264# dout[3] 3.56957f
C1258 a_60908_1200# a_58508_1200# 0.0395f
C1259 a_16508_54400# a_17708_54400# 0.42392f
C1260 dout[1] dout[6] 0.11474f
C1261 dout[0] dout[7] 0.1132f
C1262 comp_out_p dout[5] 2.61771f
C1263 dout[6] a_47028_19064# 3.43414f
C1264 a_3428_10824# a_4508_10960# 0.04931f
C1265 a_2228_10824# a_8108_10960# 0.34742f
C1266 comp_out_p a_5708_6160# 0.0894f
C1267 dac_in[2] dac_in[5] 0.06127f
C1268 dac_in[3] dac_in[4] 25.6599f
C1269 done a_34108_29600# 0.02619f
C1270 rst_latch a_49708_41600# 0.03145f
C1271 a_14908_6160# a_17308_6160# 1.27786f
C1272 a_58628_9464# a_59828_9464# 0.90775f
C1273 a_23428_54264# a_43828_54264# 0.1362f
C1274 comp_done a_49708_29600# 0.0193f
C1275 a_50908_37600# dout[5] 0.07357f
C1276 a_19708_41600# dout[2] 0.03084f
C1277 a_23428_10824# a_22108_10960# 0.26027f
C1278 rst_latch done 16.3074f
C1279 dac_in[4] a_35308_29600# 0.06119f
C1280 a_32694_53200# a_33308_19200# 0.01142f
C1281 a_34108_33600# dout[5] 0.09997f
C1282 a_4508_20560# a_2228_20424# 0.24111f
C1283 a_2908_33600# comp_out_p 1.86716f
C1284 a_23428_54264# a_23308_50400# 0.9987f
C1285 a_40508_1200# a_41708_1200# 1.00702f
C1286 a_20908_46000# dac_in[3] 0.06756f
C1287 a_33308_24800# a_43708_50400# 0.02638f
C1288 a_45428_3864# a_46628_3864# 0.90778f
C1289 a_9308_15760# a_9494_14400# 0.03324f
C1290 a_50228_15064# a_51428_15064# 0.90778f
C1291 a_50628_54264# dout[1] 0.12065f
C1292 a_50628_54264# a_47028_19064# 0.1934f
C1293 a_54908_6800# a_56108_6800# 1.00702f
C1294 comp_out_p a_2228_6024# 0.06215f
C1295 a_9308_10960# a_9494_9600# 0.03324f
C1296 a_42908_6800# a_44108_6800# 1.00702f
C1297 a_51708_54400# a_53094_53200# 0.0129f
C1298 a_39308_6800# a_40508_6800# 1.00762f
C1299 a_40508_6800# a_42908_6800# 0.04266f
C1300 a_23308_54400# comp_out_p 0.02113f
C1301 a_3028_54264# a_5494_49200# 0.03268f
C1302 dout[0] a_4108_54400# 0.02844f
C1303 a_3428_10824# a_2108_10960# 0.02521f
C1304 comp_out_p a_3308_6160# 0.02929f
C1305 a_2228_10824# a_4508_10960# 0.24111f
C1306 dout[6] a_41308_37600# 0.03674f
C1307 a_23428_54264# dac_in[4] 0.13593f
C1308 dout[4] a_16628_54264# 0.12915f
C1309 a_20908_46000# a_35308_29600# 1.08069f
C1310 dout[5] dac_in[2] 0.06119f
C1311 dout[3] dout[4] 25.7224f
C1312 rst_latch a_48508_41600# 0.02515f
C1313 dout[1] a_37028_54264# 0.12238f
C1314 a_47028_19064# a_37028_54264# 0.13435f
C1315 a_16228_6024# a_17308_6160# 0.04931f
C1316 dout[2] a_9828_54264# 0.12675f
C1317 comp_done a_48508_29600# 0.03131f
C1318 a_49708_37600# dout[5] 0.0722f
C1319 dac_in[5] a_39494_53200# 0.03268f
C1320 comp_done a_33308_19200# 1.01622f
C1321 a_20908_10960# a_22108_10960# 2.73702f
C1322 dout[4] a_43828_54264# 0.17764f
C1323 a_33308_24800# dout[0] 0.24993f
C1324 a_50228_9464# a_49028_9464# 0.90775f
C1325 a_23428_54264# a_20908_46000# 0.13273f
C1326 a_33308_24800# a_38108_50400# 0.01943f
C1327 a_51708_54400# a_43828_54264# 0.06426f
C1328 a_41708_6800# a_44108_6800# 0.04266f
C1329 a_51094_36400# a_50908_37600# 0.03264f
C1330 a_40508_6800# a_41708_6800# 1.00702f
C1331 a_53708_6800# a_56108_6800# 0.04266f
C1332 a_11308_46000# a_13708_46000# 0.04266f
C1333 a_38108_6800# a_40508_6800# 0.04266f
C1334 a_59708_12400# a_60908_12400# 0.96154f
C1335 a_2228_10824# a_2108_10960# 3.2367f
C1336 dout[6] a_34108_37600# 0.09997f
C1337 dac_in[5] a_16628_54264# 0.13593f
C1338 a_57428_9464# a_58628_9464# 0.90778f
C1339 dout[2] dac_in[6] 0.05879f
C1340 dout[3] dac_in[5] 0.06032f
C1341 comp_out_p a_30228_54264# 1.10652f
C1342 dout[4] dac_in[4] 0.06119f
C1343 a_16228_6024# a_14908_6160# 0.02521f
C1344 comp_out_p dac_in[7] 0.54414f
C1345 a_48508_37600# dout[5] 0.12453f
C1346 a_34108_29600# a_41308_29600# 1.00249f
C1347 a_11308_46000# a_10108_46000# 1.00702f
C1348 a_20908_10960# a_23428_10824# 0.08029f
C1349 dac_in[3] a_9828_54264# 0.13507f
C1350 a_50508_50400# a_51708_50400# 0.42392f
C1351 a_35828_9464# a_37028_9464# 0.90778f
C1352 a_17708_54400# comp_out_p 0.03999f
C1353 dac_in[5] a_43828_54264# 0.26093f
C1354 a_9828_54264# a_35308_29600# 0.11565f
C1355 a_49028_15064# a_50228_15064# 0.90775f
C1356 a_8108_15760# a_9494_14400# 0.05987f
C1357 a_8108_10960# a_9494_9600# 0.05987f
C1358 a_51094_36400# a_49708_37600# 0.0129f
C1359 a_39308_6800# a_41708_6800# 0.04266f
C1360 dac_in[0] dout[2] 0.05879f
C1361 a_53708_6800# a_54908_6800# 1.00762f
C1362 a_41708_6800# a_42908_6800# 1.00762f
C1363 dac_in[1] comp_out_p 2.44146f
C1364 a_38108_6800# a_39308_6800# 1.00702f
C1365 a_11308_46000# a_12508_46000# 1.00762f
C1366 a_20908_46000# dout[4] 0.17416f
C1367 a_58508_12400# a_60908_12400# 0.0395f
C1368 a_54908_12400# sample_en 0.01711f
C1369 a_2228_10824# a_3428_10824# 0.03237f
C1370 a_34628_3864# a_33428_3864# 0.90778f
C1371 a_41308_41600# a_35308_29600# 0.03334f
C1372 a_33308_19200# a_3028_54264# 0.12734f
C1373 a_26908_1360# a_24508_1360# 1.03812f
C1374 dout[5] a_16628_54264# 0.12915f
C1375 dout[0] done 0.12157f
C1376 comp_out_p dout[7] 2.20367f
C1377 comp_done a_47028_19064# 2.46555f
C1378 a_43708_37600# dout[5] 0.03546f
C1379 dout[1] comp_done 0.12157f
C1380 dout[2] dout[6] 0.11491f
C1381 dout[3] dout[5] 0.1164f
C1382 a_11308_46000# a_8908_46000# 0.04266f
C1383 dac_in[3] dac_in[6] 0.06051f
C1384 dac_in[2] dac_in[7] 0.06119f
C1385 dac_in[4] dac_in[5] 25.6598f
C1386 comp_out_p a_35494_32400# 0.06392f
C1387 dac_in[2] a_30228_54264# 0.12915f
C1388 a_23428_54264# a_9828_54264# 0.13674f
C1389 sample_en a_51708_50400# 0.01897f
C1390 dac_in[5] a_38108_54400# 0.80903f
C1391 comp_done a_49708_33600# 0.0193f
C1392 a_18508_6160# comp_out_p 0.05147f
C1393 dout[5] a_43828_54264# 0.18393f
C1394 a_51094_32400# dout[4] 0.01941f
C1395 a_17708_54400# dac_in[2] 0.80903f
C1396 sample_en a_53828_3864# 0.12842f
C1397 dac_in[6] a_35308_29600# 0.05887f
C1398 a_36908_6800# a_39308_6800# 0.04266f
C1399 a_43894_28400# a_33308_24800# 0.01137f
C1400 dac_in[1] dac_in[2] 25.6599f
C1401 a_52508_6800# a_54908_6800# 0.04266f
C1402 a_46508_6800# a_48908_6800# 0.04266f
C1403 dac_in[0] dac_in[3] 0.06137f
C1404 dout[6] a_51094_40400# 0.01226f
C1405 a_58508_12400# a_59708_12400# 1.0077f
C1406 a_20908_46000# dac_in[5] 0.12286f
C1407 a_53708_12400# sample_en 0.0461f
C1408 a_50628_54264# dout[2] 0.12065f
C1409 comp_out_p a_42508_41600# 0.02387f
C1410 a_38908_41600# a_35308_29600# 0.0235f
C1411 a_16108_10960# a_35308_29600# 0.03541f
C1412 a_26908_1360# a_25828_1224# 0.04888f
C1413 a_10908_54400# a_12294_53200# 0.0129f
C1414 a_13708_46000# a_14908_46000# 1.00762f
C1415 a_23308_54400# dout[3] 0.03349f
C1416 a_56228_9464# a_57428_9464# 0.90775f
C1417 a_42508_37600# dout[5] 0.04175f
C1418 a_41308_33600# a_33308_24800# 0.03222f
C1419 a_23428_54264# dac_in[6] 0.13593f
C1420 dac_in[0] a_35308_29600# 0.05441f
C1421 dout[7] dac_in[2] 0.06155f
C1422 dout[6] dac_in[3] 0.06119f
C1423 dout[5] dac_in[4] 0.06119f
C1424 a_14908_10960# a_35308_29600# 0.01927f
C1425 dout[2] a_37028_54264# 0.12238f
C1426 a_2108_10960# a_33308_19200# 0.02806f
C1427 a_34628_9464# a_35828_9464# 0.90775f
C1428 comp_done a_48508_33600# 0.03074f
C1429 dout[4] a_9828_54264# 0.12675f
C1430 sample_en a_33308_19200# 0.26103f
C1431 sample_en a_52628_3864# 0.07335f
C1432 a_47828_15064# a_49028_15064# 0.90778f
C1433 dout[6] a_35308_29600# 0.27519f
C1434 a_6508_46000# a_8908_46000# 0.04266f
C1435 a_33308_24800# comp_out_p 11.5727f
C1436 a_36908_6800# a_38108_6800# 1.00762f
C1437 dac_in[7] a_53094_53200# 0.03268f
C1438 a_37028_54264# a_36908_50400# 0.99875f
C1439 a_46508_6800# a_47708_6800# 1.00762f
C1440 a_36908_1200# a_38108_1200# 1.00762f
C1441 a_23428_54264# dac_in[0] 0.12915f
C1442 a_52508_6800# a_53708_6800# 1.00702f
C1443 a_57308_12400# a_59708_12400# 0.04266f
C1444 sample_en a_43708_54400# 0.03283f
C1445 a_52508_12400# sample_en 0.01311f
C1446 a_47028_19064# a_3028_54264# 0.12157f
C1447 dout[1] a_3028_54264# 0.49613f
C1448 a_20908_46000# dout[5] 0.16738f
C1449 a_34108_41600# a_35308_29600# 0.11376f
C1450 a_26908_1360# a_23308_1360# 0.04749f
C1451 a_12508_46000# a_14908_46000# 0.04266f
C1452 a_50628_54264# dac_in[3] 0.12656f
C1453 a_33308_19200# a_32694_49200# 0.01142f
C1454 a_34108_33600# a_33308_24800# 0.23155f
C1455 comp_done a_34108_37600# 0.03012f
C1456 a_16228_10824# a_35308_29600# 0.01824f
C1457 a_17308_41600# a_18508_41600# 0.42399f
C1458 a_23428_54264# dout[6] 0.12915f
C1459 a_42908_19200# a_33308_24800# 0.0148f
C1460 dac_in[7] a_16628_54264# 0.13611f
C1461 a_16628_54264# a_30228_54264# 0.13674f
C1462 dac_in[0] a_5494_53200# 0.03268f
C1463 dout[3] dac_in[7] 0.06119f
C1464 dout[4] dac_in[6] 0.12086f
C1465 dout[3] a_30228_54264# 0.12238f
C1466 sample_en a_43708_29600# 0.0288f
C1467 a_50628_54264# a_35308_29600# 0.12065f
C1468 a_47028_19064# a_50508_50400# 0.02377f
C1469 dac_in[3] a_37028_54264# 0.12915f
C1470 sample_en a_51428_3864# 0.1799f
C1471 dac_in[5] a_9828_54264# 0.13515f
C1472 a_17708_54400# a_16628_54264# 0.04977f
C1473 a_6508_46000# a_7708_46000# 1.00762f
C1474 a_17708_54400# dout[3] 0.01279f
C1475 a_19708_33600# a_19894_32400# 0.03264f
C1476 dac_in[7] a_43828_54264# 0.18438f
C1477 a_35708_6800# a_38108_6800# 0.04266f
C1478 a_30228_54264# a_43828_54264# 0.13663f
C1479 a_33308_24800# dac_in[2] 0.13513f
C1480 a_19708_1360# a_17308_1360# 1.2778f
C1481 a_45308_6800# a_47708_6800# 0.04266f
C1482 a_57308_12400# a_58508_12400# 1.00702f
C1483 a_51308_6800# a_53708_6800# 0.04266f
C1484 a_35708_1200# a_38108_1200# 0.04266f
C1485 dout[7] a_53094_53200# 0.01107f
C1486 a_37028_54264# a_35308_29600# 0.73756f
C1487 a_49708_29600# a_50908_29600# 0.76551f
C1488 dac_in[1] a_16628_54264# 0.12915f
C1489 dout[7] a_53094_49200# 0.01314f
C1490 a_23428_54264# a_50628_54264# 0.13427f
C1491 dac_in[0] dout[4] 0.05896f
C1492 a_10908_54400# a_9828_54264# 0.06067f
C1493 dac_in[1] dout[3] 0.06119f
C1494 a_20908_1360# a_17308_1360# 0.4841f
C1495 a_12508_46000# a_13708_46000# 1.00702f
C1496 a_18508_29600# a_19708_29600# 0.76551f
C1497 a_17708_54400# a_19094_53200# 0.0129f
C1498 a_50508_54400# dout[4] 0.01772f
C1499 a_15028_10824# a_35308_29600# 0.0232f
C1500 comp_out_p a_4294_32400# 0.08198f
C1501 a_57308_12400# a_54908_12400# 0.04266f
C1502 dac_in[1] a_43828_54264# 0.12905f
C1503 a_33428_9464# a_34628_9464# 0.90778f
C1504 dout[7] a_16628_54264# 0.12915f
C1505 a_4294_40400# comp_out_p 0.03751f
C1506 sample_en a_42508_29600# 0.02319f
C1507 a_2228_10824# a_33308_19200# 0.02937f
C1508 sample_en a_47028_19064# 0.32182f
C1509 comp_out_p done 1.99767f
C1510 dout[4] dout[6] 0.20319f
C1511 dout[1] sample_en 0.24315f
C1512 dout[2] comp_done 0.12341f
C1513 dout[3] dout[7] 0.11337f
C1514 a_23428_54264# a_37028_54264# 0.13674f
C1515 dac_in[5] dac_in[6] 25.6611f
C1516 sample_en a_50228_3864# 0.07347f
C1517 dac_in[4] dac_in[7] 0.06137f
C1518 a_12508_46000# a_10108_46000# 0.04266f
C1519 dac_in[4] a_30228_54264# 3.28845f
C1520 a_50508_54400# a_51708_54400# 0.42392f
C1521 dout[5] a_9828_54264# 0.12675f
C1522 rst_latch dout[0] 0.12157f
C1523 comp_out_p a_3308_10960# 0.02746f
C1524 a_19708_1360# a_18628_1224# 0.04931f
C1525 a_18508_33600# a_19894_32400# 0.0129f
C1526 a_35708_6800# a_36908_6800# 1.00702f
C1527 a_53708_12400# a_54908_12400# 1.00762f
C1528 dout[1] a_9708_54400# 0.01848f
C1529 a_50908_37600# done 0.0288f
C1530 a_40908_24800# a_20908_46000# 0.04648f
C1531 dout[7] a_43828_54264# 3.51752f
C1532 dout[6] a_51708_54400# 0.01835f
C1533 a_56108_12400# a_58508_12400# 0.04266f
C1534 a_35708_1200# a_36908_1200# 1.00702f
C1535 a_48508_29600# a_50908_29600# 0.99858f
C1536 a_8908_46000# a_10108_46000# 1.00762f
C1537 a_34108_33600# done 0.02619f
C1538 a_51308_6800# a_52508_6800# 1.00762f
C1539 a_18508_1360# a_17308_1360# 1.39926f
C1540 dac_in[1] dac_in[4] 0.06137f
C1541 dac_in[0] dac_in[5] 0.06109f
C1542 a_43708_50400# a_44908_50400# 0.42392f
C1543 a_17308_29600# a_19708_29600# 0.99858f
C1544 a_50628_54264# dout[4] 0.17913f
C1545 a_20908_46000# dac_in[7] 0.06756f
C1546 a_20908_46000# a_30228_54264# 0.13273f
C1547 comp_out_p a_11308_46000# 0.035f
C1548 a_56108_12400# a_54908_12400# 1.00702f
C1549 dout[0] a_19708_29600# 1.09035f
C1550 dac_in[1] a_12294_53200# 0.03268f
C1551 sample_en a_41308_37600# 0.02104f
C1552 sample_en a_49028_3864# 1.1129f
C1553 dout[7] dac_in[4] 0.06119f
C1554 dout[6] dac_in[5] 0.23474f
C1555 done dac_in[2] 0.06756f
C1556 comp_done dac_in[3] 0.06893f
C1557 a_50628_54264# a_51708_54400# 0.04466f
C1558 dout[5] dac_in[6] 0.12086f
C1559 a_17308_6160# comp_out_p 0.03909f
C1560 dout[4] a_37028_54264# 0.12238f
C1561 a_25894_53200# dac_in[3] 0.03268f
C1562 dac_in[5] a_36908_54400# 0.99858f
C1563 a_49708_37600# done 0.02273f
C1564 a_34508_1200# a_36908_1200# 0.04266f
C1565 a_39708_24800# a_20908_46000# 1.01288f
C1566 a_52508_12400# a_54908_12400# 0.04266f
C1567 a_20908_46000# dac_in[1] 0.06079f
C1568 a_56108_12400# a_57308_12400# 1.00762f
C1569 a_48508_29600# a_49708_29600# 0.42399f
C1570 a_33308_24800# a_16628_54264# 0.24993f
C1571 a_50108_6800# a_52508_6800# 0.04266f
C1572 a_7708_46000# a_10108_46000# 0.04266f
C1573 comp_done a_35308_29600# 0.20788f
C1574 a_43708_37600# a_33308_24800# 0.0362f
C1575 a_33308_24800# dout[3] 0.2567f
C1576 a_18508_1360# a_18628_1224# 1.05947f
C1577 a_52628_3864# a_53828_3864# 0.90778f
C1578 a_17308_29600# a_18508_29600# 0.42399f
C1579 dac_in[0] dout[5] 0.05915f
C1580 dout[2] a_3028_54264# 0.12915f
C1581 a_20908_46000# dout[7] 0.16744f
C1582 a_33308_24800# a_43828_54264# 0.32562f
C1583 a_56108_12400# a_53708_12400# 0.04266f
C1584 a_50628_54264# dac_in[5] 0.12656f
C1585 a_50508_54400# dout[5] 0.01789f
C1586 dout[0] a_18508_29600# 1.03879f
C1587 sample_en a_46628_3864# 0.91292f
C1588 sample_en a_34108_37600# 0.02298f
C1589 a_5308_46000# a_6508_46000# 1.00702f
C1590 a_23428_54264# comp_done 0.13273f
C1591 dout[5] dout[6] 31.3959f
C1592 a_35494_40400# comp_out_p 0.03751f
C1593 a_14908_6160# comp_out_p 0.06957f
C1594 sample_en a_43708_33600# 0.0288f
C1595 a_20908_15760# a_23428_15624# 0.08029f
C1596 comp_out_p a_6508_46000# 0.0953f
C1597 a_48508_37600# done 0.01843f
C1598 a_43708_54400# a_44908_54400# 0.42392f
C1599 dac_in[5] a_37028_54264# 3.38875f
C1600 a_52508_12400# a_53708_12400# 1.00702f
C1601 a_34508_1200# a_35708_1200# 1.00762f
C1602 a_30228_54264# a_9828_54264# 0.1363f
C1603 dac_in[7] a_9828_54264# 0.13547f
C1604 a_50108_6800# a_51308_6800# 1.00702f
C1605 a_47028_19064# a_50908_29600# 0.0287f
C1606 a_7708_46000# a_8908_46000# 1.00702f
C1607 a_42508_37600# a_33308_24800# 0.05968f
C1608 a_3308_15760# a_5708_15760# 0.06606f
C1609 a_20908_46000# a_42508_41600# 0.0117f
C1610 a_17308_46000# a_14908_46000# 0.04266f
C1611 a_33308_24800# dac_in[4] 0.1748f
C1612 a_45428_15064# a_46628_15064# 0.90778f
C1613 a_11308_41600# a_12508_41600# 0.76551f
C1614 a_33308_24800# a_38108_54400# 0.01943f
C1615 dac_in[3] a_3028_54264# 0.13507f
C1616 a_50628_54264# dout[5] 0.18097f
C1617 dout[0] a_17308_29600# 0.03674f
C1618 dac_in[1] a_9828_54264# 3.1619f
C1619 a_17308_41600# dout[1] 0.02299f
C1620 a_4108_46000# a_6508_46000# 0.04266f
C1621 a_16228_6024# comp_out_p 0.01659f
C1622 comp_out_p a_14908_46000# 0.07153f
C1623 done a_16628_54264# 0.12157f
C1624 sample_en a_42508_33600# 0.0229f
C1625 comp_out_p a_34108_29600# 0.05094f
C1626 dout[2] sample_en 0.24682f
C1627 a_47028_19064# a_51708_50400# 0.01926f
C1628 a_51308_12400# a_53708_12400# 0.04266f
C1629 a_33308_24800# a_20908_46000# 1.97815f
C1630 a_3028_54264# a_35308_29600# 0.1156f
C1631 dout[3] done 0.12835f
C1632 dout[4] comp_done 0.37842f
C1633 dac_in[6] dac_in[7] 25.6608f
C1634 dout[5] a_37028_54264# 3.7244f
C1635 a_33308_1200# a_35708_1200# 0.04266f
C1636 dac_in[6] a_30228_54264# 0.13593f
C1637 dout[7] a_9828_54264# 0.12675f
C1638 a_47028_19064# a_49708_29600# 0.02848f
C1639 a_48908_6800# a_51308_6800# 0.04266f
C1640 rst_latch comp_out_p 3.24734f
C1641 a_16108_46000# a_14908_46000# 1.00702f
C1642 a_25894_53200# a_24508_54400# 0.0129f
C1643 a_18508_15760# a_16108_15760# 0.06606f
C1644 a_23308_1360# a_17308_1360# 0.29742f
C1645 a_51428_3864# a_52628_3864# 0.90775f
C1646 done a_43828_54264# 0.18953f
C1647 a_10108_41600# a_12508_41600# 0.99858f
C1648 a_41308_41600# dout[7] 0.03674f
C1649 a_23428_54264# a_3028_54264# 0.1363f
C1650 a_16508_54400# dout[0] 0.01819f
C1651 dac_in[0] dac_in[7] 0.06119f
C1652 a_3428_15624# a_2108_15760# 0.02521f
C1653 dac_in[1] dac_in[6] 0.06032f
C1654 a_4294_40400# a_4108_41600# 0.04392f
C1655 dac_in[0] a_30228_54264# 0.12915f
C1656 comp_out_p a_13708_46000# 0.01514f
C1657 a_50508_54400# dac_in[7] 0.99858f
C1658 comp_out_p a_19708_29600# 0.01936f
C1659 comp_out_p a_17308_10960# 0.03758f
C1660 a_51308_12400# a_52508_12400# 1.00762f
C1661 a_33308_1200# a_34508_1200# 1.00709f
C1662 a_12694_36400# a_12508_37600# 0.03264f
C1663 dout[6] dac_in[7] 0.07964f
C1664 sample_en dac_in[3] 0.13513f
C1665 a_47028_19064# a_48508_29600# 0.02674f
C1666 done dac_in[4] 0.21454f
C1667 comp_done dac_in[5] 0.06079f
C1668 dout[7] dac_in[6] 0.89156f
C1669 dout[1] a_33308_19200# 0.12157f
C1670 dout[6] a_30228_54264# 0.12915f
C1671 a_48908_6800# a_50108_6800# 1.00762f
C1672 a_47028_19064# a_33308_19200# 0.12749f
C1673 a_16108_46000# a_13708_46000# 0.04266f
C1674 dac_in[0] dac_in[1] 25.6599f
C1675 a_41308_41600# a_42508_41600# 0.42399f
C1676 a_15028_15624# a_16108_15760# 0.25574f
C1677 comp_out_p a_10108_46000# 0.09991f
C1678 rst_latch dac_in[2] 0.06756f
C1679 a_30228_54264# a_36908_54400# 0.0406f
C1680 a_44228_15064# a_45428_15064# 0.90775f
C1681 comp_out_p a_44908_50400# 0.98748f
C1682 a_10108_41600# a_11308_41600# 0.42399f
C1683 sample_en a_35308_29600# 0.61498f
C1684 a_49708_37600# rst_latch 0.03145f
C1685 a_51308_12400# a_48908_12400# 0.04266f
C1686 a_38908_41600# dout[7] 1.26823f
C1687 a_2228_15624# a_2108_15760# 3.2367f
C1688 a_33308_24800# a_9828_54264# 0.2567f
C1689 dac_in[0] dout[7] 25.6588f
C1690 dac_in[1] dout[6] 0.06155f
C1691 dout[4] a_3028_54264# 0.12915f
C1692 a_20908_46000# done 0.13245f
C1693 a_50628_54264# a_30228_54264# 0.13446f
C1694 a_50628_54264# dac_in[7] 3.64994f
C1695 a_50508_54400# dout[7] 0.01387f
C1696 comp_out_p a_18508_29600# 0.07684f
C1697 a_47708_12400# a_48908_12400# 1.00702f
C1698 a_14908_15760# a_20908_15760# 0.29742f
C1699 a_41308_41600# a_33308_24800# 0.02846f
C1700 a_50108_12400# a_52508_12400# 0.04266f
C1701 a_19894_28400# a_19708_29600# 0.03264f
C1702 a_12694_36400# a_11308_37600# 0.0129f
C1703 a_42508_29600# a_43708_29600# 0.76551f
C1704 a_23428_54264# sample_en 0.26545f
C1705 a_18508_41600# dout[2] 0.08797f
C1706 a_47708_6800# a_50108_6800# 0.04266f
C1707 dout[5] comp_done 0.37164f
C1708 dout[6] dout[7] 30.8291f
C1709 a_18508_46000# a_19708_46000# 1.0077f
C1710 dac_in[7] a_37028_54264# 0.13593f
C1711 dout[4] a_50508_50400# 0.01851f
C1712 a_50228_3864# a_51428_3864# 0.90778f
C1713 comp_out_p a_8908_46000# 0.0527f
C1714 a_30228_54264# a_37028_54264# 25.845f
C1715 a_47028_19064# a_50908_33600# 0.02013f
C1716 comp_out_p a_43708_50400# 0.05216f
C1717 a_50108_12400# a_48908_12400# 1.00762f
C1718 a_50628_54264# dac_in[1] 0.12656f
C1719 a_34108_41600# dout[7] 0.09997f
C1720 rst_latch start 14.46f
C1721 sample_en start 54.0563f
C1722 done start 24.4136f
C1723 comp_done start 35.1471f
C1724 dout[7] start 20.9147f
C1725 dout[6] start 21.1932f
C1726 dout[5] start 22.1542f
C1727 dout[4] start 24.7969f
C1728 dout[3] start 20.662f
C1729 dout[2] start 17.9353f
C1730 comp_out_p start 0.31033p
C1731 dout[1] start 18.9255f
C1732 dout[0] start 49.3837f
C1733 dac_in[7] start 11.1279f
C1734 dac_in[6] start 10.5898f
C1735 dac_in[5] start 12.8232f
C1736 dac_in[4] start 13.0183f
C1737 dac_in[3] start 10.5008f
C1738 dac_in[2] start 10.3929f
C1739 dac_in[1] start 8.85179f
C1740 dac_in[0] start 9.61647f
C1741 a_24694_0# start 0.47947f
C1742 a_10694_0# start 0.57352f
C1743 a_60908_1200# start 0.46919f
C1744 a_59708_1200# start 1.54607f
C1745 a_58508_1200# start 1.42195f
C1746 a_57308_1200# start 1.42952f
C1747 a_56108_1200# start 1.41742f
C1748 a_54908_1200# start 1.42952f
C1749 a_53708_1200# start 1.41742f
C1750 a_52508_1200# start 1.42952f
C1751 a_51308_1200# start 1.41742f
C1752 a_50108_1200# start 1.42952f
C1753 a_48908_1200# start 1.40446f
C1754 a_47708_1200# start 1.42441f
C1755 a_46508_1200# start 1.41742f
C1756 a_45308_1200# start 1.42952f
C1757 a_44108_1200# start 1.41742f
C1758 a_42908_1200# start 1.42952f
C1759 a_41708_1200# start 1.41742f
C1760 a_40508_1200# start 1.42952f
C1761 a_39308_1200# start 1.41742f
C1762 a_38108_1200# start 1.42952f
C1763 a_36908_1200# start 1.41742f
C1764 a_35708_1200# start 1.43359f
C1765 a_34508_1200# start 1.49067f
C1766 a_33308_1200# start 2.54697f
C1767 a_26908_1360# start 0.53934f
C1768 a_20908_1360# start 3.70183f
C1769 a_18508_1360# start 1.34703f
C1770 a_24508_1360# start 3.88788f
C1771 a_25828_1224# start 0.79594f
C1772 a_23308_1360# start 2.79472f
C1773 a_19708_1360# start 2.05539f
C1774 a_17308_1360# start 4.82908f
C1775 a_18628_1224# start 0.74088f
C1776 a_11828_1424# start 1.37077f
C1777 a_3428_1424# start 8.61546f
C1778 a_2228_1424# start 2.0417f
C1779 a_33308_4000# start 0.56138f
C1780 a_61028_3864# start 0.72867f
C1781 a_59828_3864# start 1.41824f
C1782 a_58628_3864# start 1.39403f
C1783 a_57428_3864# start 1.38696f
C1784 a_56228_3864# start 1.39004f
C1785 a_55028_3864# start 1.38696f
C1786 a_53828_3864# start 1.39004f
C1787 a_52628_3864# start 1.38696f
C1788 a_51428_3864# start 1.39004f
C1789 a_50228_3864# start 1.38696f
C1790 a_49028_3864# start 1.38376f
C1791 a_46628_3864# start 1.38933f
C1792 a_45428_3864# start 1.38696f
C1793 a_44228_3864# start 1.39004f
C1794 a_43028_3864# start 1.38696f
C1795 a_41828_3864# start 1.39004f
C1796 a_40628_3864# start 1.38696f
C1797 a_39428_3864# start 1.39004f
C1798 a_38228_3864# start 1.38696f
C1799 a_37028_3864# start 1.39004f
C1800 a_35828_3864# start 1.39022f
C1801 a_34628_3864# start 1.41586f
C1802 a_33428_3864# start 1.46208f
C1803 a_22294_4800# start 0.45292f
C1804 a_9494_4800# start 0.45292f
C1805 a_24508_6160# start 0.51324f
C1806 a_18508_6160# start 2.85f
C1807 a_16108_6160# start 1.04419f
C1808 a_11708_6160# start 0.51324f
C1809 a_5708_6160# start 2.85f
C1810 a_3308_6160# start 1.09966f
C1811 a_22108_6160# start 3.6911f
C1812 a_23428_6024# start 0.77844f
C1813 a_20908_6160# start 2.40038f
C1814 a_17308_6160# start 1.76343f
C1815 a_14908_6160# start 1.54467f
C1816 a_16228_6024# start 0.68624f
C1817 a_15028_6024# start 2.81155f
C1818 a_9308_6160# start 3.68446f
C1819 a_10628_6024# start 0.77844f
C1820 a_8108_6160# start 2.40038f
C1821 a_4508_6160# start 1.77802f
C1822 a_2108_6160# start 1.68728f
C1823 a_3428_6024# start 0.7115f
C1824 a_2228_6024# start 2.9156f
C1825 a_60908_6800# start 0.46288f
C1826 a_59708_6800# start 1.53471f
C1827 a_58508_6800# start 1.41854f
C1828 a_57308_6800# start 1.41764f
C1829 a_56108_6800# start 1.41401f
C1830 a_54908_6800# start 1.41764f
C1831 a_53708_6800# start 1.41401f
C1832 a_52508_6800# start 1.41764f
C1833 a_51308_6800# start 1.41401f
C1834 a_50108_6800# start 1.41764f
C1835 a_48908_6800# start 1.41401f
C1836 a_47708_6800# start 1.41764f
C1837 a_46508_6800# start 1.41401f
C1838 a_45308_6800# start 1.41764f
C1839 a_44108_6800# start 1.41401f
C1840 a_42908_6800# start 1.41764f
C1841 a_41708_6800# start 1.41401f
C1842 a_40508_6800# start 1.41764f
C1843 a_39308_6800# start 1.41401f
C1844 a_38108_6800# start 1.41764f
C1845 a_36908_6800# start 1.41401f
C1846 a_35708_6800# start 1.42171f
C1847 a_34508_6800# start 1.44748f
C1848 a_33308_6800# start 1.58823f
C1849 a_33428_6664# start 0.64575f
C1850 a_33308_9600# start 0.56164f
C1851 a_22294_9600# start 0.45292f
C1852 a_61028_9464# start 0.72861f
C1853 a_59828_9464# start 1.42401f
C1854 a_58628_9464# start 1.39678f
C1855 a_57428_9464# start 1.39273f
C1856 a_56228_9464# start 1.3928f
C1857 a_55028_9464# start 1.39273f
C1858 a_53828_9464# start 1.3928f
C1859 a_52628_9464# start 1.39273f
C1860 a_51428_9464# start 1.3928f
C1861 a_50228_9464# start 1.39273f
C1862 a_49028_9464# start 1.3928f
C1863 a_47828_9464# start 1.39273f
C1864 a_46628_9464# start 1.3928f
C1865 a_45428_9464# start 1.39273f
C1866 a_44228_9464# start 1.3928f
C1867 a_43028_9464# start 1.39273f
C1868 a_41828_9464# start 1.3928f
C1869 a_40628_9464# start 1.39273f
C1870 a_39428_9464# start 1.3928f
C1871 a_38228_9464# start 1.39273f
C1872 a_37028_9464# start 1.3928f
C1873 a_35828_9464# start 1.39598f
C1874 a_34628_9464# start 1.41862f
C1875 a_33428_9464# start 1.46736f
C1876 a_9494_9600# start 0.45292f
C1877 a_24508_10960# start 0.51324f
C1878 a_18508_10960# start 2.85f
C1879 a_16108_10960# start 1.04419f
C1880 a_11708_10960# start 0.51324f
C1881 a_5708_10960# start 2.85f
C1882 a_3308_10960# start 1.09424f
C1883 a_22108_10960# start 3.6911f
C1884 a_23428_10824# start 0.77844f
C1885 a_20908_10960# start 2.40038f
C1886 a_17308_10960# start 1.76343f
C1887 a_14908_10960# start 1.54467f
C1888 a_16228_10824# start 0.69139f
C1889 a_15028_10824# start 2.82959f
C1890 a_9308_10960# start 3.68446f
C1891 a_10628_10824# start 0.77844f
C1892 a_8108_10960# start 2.40038f
C1893 a_4508_10960# start 1.77802f
C1894 a_2108_10960# start 1.67735f
C1895 a_3428_10824# start 0.7096f
C1896 a_2228_10824# start 2.91268f
C1897 a_60908_12400# start 0.46288f
C1898 a_59708_12400# start 1.53471f
C1899 a_58508_12400# start 1.41854f
C1900 a_57308_12400# start 1.41764f
C1901 a_56108_12400# start 1.41401f
C1902 a_54908_12400# start 1.41764f
C1903 a_53708_12400# start 1.41401f
C1904 a_52508_12400# start 1.41764f
C1905 a_51308_12400# start 1.41401f
C1906 a_50108_12400# start 1.41764f
C1907 a_48908_12400# start 1.41401f
C1908 a_47708_12400# start 1.41764f
C1909 a_46508_12400# start 1.41401f
C1910 a_45308_12400# start 1.41764f
C1911 a_44108_12400# start 1.41401f
C1912 a_42908_12400# start 1.41764f
C1913 a_41708_12400# start 1.41465f
C1914 a_40508_12400# start 1.41828f
C1915 a_39308_12400# start 1.41465f
C1916 a_38108_12400# start 1.41828f
C1917 a_36908_12400# start 1.41465f
C1918 a_35708_12400# start 1.42234f
C1919 a_34508_12400# start 1.44812f
C1920 a_33308_12400# start 1.58887f
C1921 a_33428_12264# start 0.64638f
C1922 a_22294_14400# start 0.45292f
C1923 a_9494_14400# start 0.45292f
C1924 a_44108_15200# start 0.4486f
C1925 a_61028_15064# start 0.72909f
C1926 a_59828_15064# start 1.42448f
C1927 a_58628_15064# start 1.39888f
C1928 a_57428_15064# start 1.3932f
C1929 a_56228_15064# start 1.39489f
C1930 a_55028_15064# start 1.3932f
C1931 a_53828_15064# start 1.39489f
C1932 a_52628_15064# start 1.3932f
C1933 a_51428_15064# start 1.39489f
C1934 a_50228_15064# start 1.3932f
C1935 a_49028_15064# start 1.39489f
C1936 a_47828_15064# start 1.3932f
C1937 a_46628_15064# start 1.39489f
C1938 a_45428_15064# start 1.39903f
C1939 a_44228_15064# start 1.40968f
C1940 a_24508_15760# start 0.51324f
C1941 a_18508_15760# start 2.85f
C1942 a_16108_15760# start 1.04419f
C1943 a_11708_15760# start 0.51324f
C1944 a_5708_15760# start 2.85f
C1945 a_3308_15760# start 1.09424f
C1946 a_22108_15760# start 3.6911f
C1947 a_23428_15624# start 0.77844f
C1948 a_20908_15760# start 2.40038f
C1949 a_17308_15760# start 1.76343f
C1950 a_14908_15760# start 1.54467f
C1951 a_16228_15624# start 0.69139f
C1952 a_15028_15624# start 2.82959f
C1953 a_9308_15760# start 3.68446f
C1954 a_10628_15624# start 0.77844f
C1955 a_8108_15760# start 2.40038f
C1956 a_4508_15760# start 1.77802f
C1957 a_2108_15760# start 1.67735f
C1958 a_3428_15624# start 0.7096f
C1959 a_2228_15624# start 2.91268f
C1960 a_43094_18000# start 0.57038f
C1961 a_42908_19200# start 2.02118f
C1962 a_33308_19200# start 40.4294f
C1963 a_9494_19200# start 0.45292f
C1964 a_47028_19064# start 42.707f
C1965 a_11708_20560# start 0.43595f
C1966 a_5708_20560# start 2.85f
C1967 a_3308_20560# start 1.09424f
C1968 a_9308_20560# start 3.69156f
C1969 a_10628_20424# start 0.78287f
C1970 a_8108_20560# start 2.40735f
C1971 a_4508_20560# start 1.77802f
C1972 a_2108_20560# start 1.67735f
C1973 a_3428_20424# start 0.7096f
C1974 a_2228_20424# start 2.91268f
C1975 a_42294_23600# start 0.55342f
C1976 a_35894_23600# start 0.54879f
C1977 a_40908_24800# start 2.54393f
C1978 a_39708_24800# start 1.76908f
C1979 a_35708_24800# start 1.10375f
C1980 a_33308_24800# start 81.8505f
C1981 a_51094_28400# start 0.55293f
C1982 a_43894_28400# start 0.55293f
C1983 a_35494_28400# start 0.58065f
C1984 a_19894_28400# start 0.55293f
C1985 a_12694_28400# start 0.55293f
C1986 a_4294_28400# start 0.58233f
C1987 a_50908_29600# start 1.85264f
C1988 a_49708_29600# start 1.54511f
C1989 a_48508_29600# start 1.70039f
C1990 a_43708_29600# start 1.90207f
C1991 a_42508_29600# start 1.54609f
C1992 a_41308_29600# start 1.72633f
C1993 a_34108_29600# start 5.38837f
C1994 a_19708_29600# start 1.85264f
C1995 a_18508_29600# start 1.54511f
C1996 a_17308_29600# start 1.69613f
C1997 a_12508_29600# start 1.85264f
C1998 a_11308_29600# start 1.54859f
C1999 a_10108_29600# start 1.7192f
C2000 a_2908_29600# start 5.50749f
C2001 a_51094_32400# start 0.55293f
C2002 a_43894_32400# start 0.55293f
C2003 a_35494_32400# start 0.56914f
C2004 a_19894_32400# start 0.55293f
C2005 a_12694_32400# start 0.55293f
C2006 a_4294_32400# start 0.57213f
C2007 a_50908_33600# start 1.80888f
C2008 a_49708_33600# start 1.4866f
C2009 a_48508_33600# start 1.55578f
C2010 a_43708_33600# start 1.85363f
C2011 a_42508_33600# start 1.48864f
C2012 a_41308_33600# start 1.59396f
C2013 a_34108_33600# start 5.40467f
C2014 a_19708_33600# start 1.80888f
C2015 a_18508_33600# start 1.4866f
C2016 a_17308_33600# start 1.55152f
C2017 a_12508_33600# start 1.80413f
C2018 a_11308_33600# start 1.4866f
C2019 a_10108_33600# start 1.58674f
C2020 a_2908_33600# start 5.52456f
C2021 a_51094_36400# start 0.55293f
C2022 a_43894_36400# start 0.55293f
C2023 a_35494_36400# start 0.57727f
C2024 a_19894_36400# start 0.55293f
C2025 a_12694_36400# start 0.55293f
C2026 a_4294_36400# start 0.57444f
C2027 a_50908_37600# start 1.80888f
C2028 a_49708_37600# start 1.4866f
C2029 a_48508_37600# start 1.55578f
C2030 a_43708_37600# start 1.85363f
C2031 a_42508_37600# start 1.48864f
C2032 a_41308_37600# start 1.59396f
C2033 a_34108_37600# start 5.42273f
C2034 a_19708_37600# start 1.80888f
C2035 a_18508_37600# start 1.4866f
C2036 a_17308_37600# start 1.55152f
C2037 a_12508_37600# start 1.80413f
C2038 a_11308_37600# start 1.4866f
C2039 a_10108_37600# start 1.58674f
C2040 a_2908_37600# start 5.54179f
C2041 a_51094_40400# start 0.55293f
C2042 a_43894_40400# start 0.55293f
C2043 a_35494_40400# start 0.57895f
C2044 a_19894_40400# start 0.55293f
C2045 a_12694_40400# start 0.55293f
C2046 a_4294_40400# start 0.57444f
C2047 a_50908_41600# start 1.80888f
C2048 a_49708_41600# start 1.4866f
C2049 a_48508_41600# start 1.55578f
C2050 a_43708_41600# start 1.85363f
C2051 a_42508_41600# start 1.48864f
C2052 a_41308_41600# start 1.59396f
C2053 a_38908_41600# start 4.80085f
C2054 a_34108_41600# start 5.46035f
C2055 a_35308_41600# start 4.06173f
C2056 a_19708_41600# start 1.80888f
C2057 a_18508_41600# start 1.4866f
C2058 a_17308_41600# start 1.55152f
C2059 a_12508_41600# start 1.80413f
C2060 a_11308_41600# start 1.4866f
C2061 a_10108_41600# start 1.58674f
C2062 a_7708_41600# start 4.65661f
C2063 a_2908_41600# start 5.57239f
C2064 a_4108_41600# start 4.0449f
C2065 a_20908_46000# start 40.1407f
C2066 a_19708_46000# start 1.43047f
C2067 a_18508_46000# start 1.42422f
C2068 a_17308_46000# start 1.37111f
C2069 a_16108_46000# start 1.41644f
C2070 a_14908_46000# start 1.37111f
C2071 a_13708_46000# start 1.41984f
C2072 a_12508_46000# start 1.37111f
C2073 a_11308_46000# start 1.41984f
C2074 a_10108_46000# start 1.44564f
C2075 a_8908_46000# start 1.46386f
C2076 a_7708_46000# start 1.43735f
C2077 a_6508_46000# start 1.43637f
C2078 a_5308_46000# start 1.52555f
C2079 a_4108_46000# start 1.52875f
C2080 a_2908_46000# start 1.58428f
C2081 a_53094_49200# start 0.55293f
C2082 a_46294_49200# start 0.57549f
C2083 a_39494_49200# start 0.56343f
C2084 a_32694_49200# start 0.57388f
C2085 a_25894_49200# start 0.55293f
C2086 a_19094_49200# start 0.55293f
C2087 a_12294_49200# start 0.55293f
C2088 a_5494_49200# start 0.57217f
C2089 a_51708_50400# start 1.55542f
C2090 a_50508_50400# start 1.68819f
C2091 a_44908_50400# start 1.63467f
C2092 a_43708_50400# start 1.7316f
C2093 a_38108_50400# start 1.59409f
C2094 a_36908_50400# start 1.72292f
C2095 a_35308_29600# start 65.0896f
C2096 a_24508_50400# start 1.55345f
C2097 a_23308_50400# start 1.68579f
C2098 a_17708_50400# start 1.5543f
C2099 a_16508_50400# start 1.68629f
C2100 a_10908_50400# start 1.55745f
C2101 a_9708_50400# start 1.73362f
C2102 a_4108_50400# start 2.63936f
C2103 a_2908_50400# start 1.87591f
C2104 a_53094_53200# start 0.55342f
C2105 a_46294_53200# start 0.57284f
C2106 a_39494_53200# start 0.56392f
C2107 a_32694_53200# start 0.57525f
C2108 a_25894_53200# start 0.55699f
C2109 a_19094_53200# start 0.56214f
C2110 a_12294_53200# start 0.55504f
C2111 a_5494_53200# start 0.57157f
C2112 a_51708_54400# start 2.54373f
C2113 a_50508_54400# start 1.76821f
C2114 a_50628_54264# start 26.211f
C2115 a_44908_54400# start 2.63707f
C2116 a_43708_54400# start 1.79707f
C2117 a_43828_54264# start 18.9498f
C2118 a_38108_54400# start 2.58032f
C2119 a_36908_54400# start 1.76706f
C2120 a_37028_54264# start 23.5584f
C2121 a_30228_54264# start 24.1963f
C2122 a_24508_54400# start 2.56462f
C2123 a_23308_54400# start 1.76235f
C2124 a_23428_54264# start 18.3052f
C2125 a_17708_54400# start 2.5693f
C2126 a_16508_54400# start 1.73919f
C2127 a_16628_54264# start 15.9597f
C2128 a_10908_54400# start 2.56021f
C2129 a_9708_54400# start 1.79097f
C2130 a_9828_54264# start 16.783f
C2131 a_4108_54400# start 2.63782f
C2132 a_2908_54400# start 1.87541f
C2133 a_3028_54264# start 17.9585f
.ends

.subckt comp_nfet$9 a_30_380# a_n84_0# a_94_0#
X0 a_94_0# a_30_380# a_n84_0# a_94_0# nfet_03v3 ad=2.112p pd=5.84u as=0.976p ps=4.42u w=1.6u l=0.28u
C0 a_30_380# a_n84_0# 0.01152f
C1 a_n84_0# a_94_0# 0.17965f
C2 a_30_380# a_94_0# 0.23058f
.ends

.subckt comp_pfet$4 a_28_n136# a_n92_0# w_n230_n138# VSUBS
X0 w_n230_n138# a_28_n136# a_n92_0# w_n230_n138# pfet_03v3 ad=5.52p pd=10.76u as=2.6p ps=9.3u w=4u l=0.28u
C0 w_n230_n138# a_28_n136# 0.17051f
C1 a_28_n136# a_n92_0# 0.02707f
C2 w_n230_n138# a_n92_0# 0.26489f
C3 a_n92_0# VSUBS 0.12084f
C4 a_28_n136# VSUBS 0.07793f
C5 w_n230_n138# VSUBS 2.4447f
.ends

.subckt comp_comp_inv_3v3 vi vdd vss vo
Xcomp_nfet$9_0 vi vo vss comp_nfet$9
Xcomp_pfet$4_0 vi vo vdd vss comp_pfet$4
C0 vi vo 0.19481f
C1 vdd vo 0.04209f
C2 vo vss 0.13251f
C3 vi vss -0.0199f
C4 vdd vss 0.02151f
.ends

.subckt comp_nfet a_n84_0# a_94_0# a_30_760#
X0 a_94_0# a_30_760# a_n84_0# a_94_0# nfet_03v3 ad=4.62p pd=9.64u as=2.135p ps=8.22u w=3.5u l=0.28u
C0 a_30_760# a_n84_0# 0.0235f
C1 a_n84_0# a_94_0# 0.34241f
C2 a_30_760# a_94_0# 0.2399f
.ends

.subckt comp_pfet$3 a_28_n136# a_n92_0# w_n230_n138# VSUBS
X0 w_n230_n138# a_28_n136# a_n92_0# w_n230_n138# pfet_03v3 ad=5.796p pd=11.16u as=2.73p ps=9.7u w=4.2u l=0.28u
C0 w_n230_n138# a_28_n136# 0.17432f
C1 a_n92_0# a_28_n136# 0.03089f
C2 a_n92_0# w_n230_n138# 0.30351f
C3 a_n92_0# VSUBS 0.13713f
C4 a_28_n136# VSUBS 0.0778f
C5 w_n230_n138# VSUBS 2.54362f
.ends

.subckt comp_nfet$6 a_n84_0# a_94_0# a_30_1660#
X0 a_94_0# a_30_1660# a_n84_0# a_94_0# nfet_03v3 ad=10.56p pd=18.64u as=4.88p ps=17.22u w=8u l=0.28u
C0 a_30_1660# a_n84_0# 0.05846f
C1 a_n84_0# a_94_0# 0.83731f
C2 a_30_1660# a_94_0# 0.27303f
.ends

.subckt comp_pfet$1 a_28_900# a_n92_0# w_n230_n138# VSUBS
X0 w_n230_n138# a_28_900# a_n92_0# w_n230_n138# pfet_03v3 ad=5.796p pd=11.16u as=2.73p ps=9.7u w=4.2u l=0.28u
C0 w_n230_n138# a_28_900# 0.17432f
C1 a_n92_0# a_28_900# 0.03089f
C2 a_n92_0# w_n230_n138# 0.30351f
C3 a_n92_0# VSUBS 0.13713f
C4 a_28_900# VSUBS 0.0778f
C5 w_n230_n138# VSUBS 2.54362f
.ends

.subckt comp_nfet$4 a_30_1260# a_n84_0# a_94_0#
X0 a_94_0# a_30_1260# a_n84_0# a_94_0# nfet_03v3 ad=7.92p pd=14.64u as=3.66p ps=13.22u w=6u l=0.28u
C0 a_30_1260# a_n84_0# 0.04298f
C1 a_n84_0# a_94_0# 0.61736f
C2 a_30_1260# a_94_0# 0.25799f
.ends

.subckt comp_nfet$2 a_30_n132# a_n84_0# a_94_0#
X0 a_94_0# a_30_n132# a_n84_0# a_94_0# nfet_03v3 ad=4.62p pd=9.64u as=2.135p ps=8.22u w=3.5u l=0.28u
C0 a_30_n132# a_n84_0# 0.0235f
C1 a_n84_0# a_94_0# 0.34241f
C2 a_30_n132# a_94_0# 0.2399f
.ends

.subckt comp_pfet a_28_n136# a_n92_0# w_n230_n138# VSUBS
X0 w_n230_n138# a_28_n136# a_n92_0# w_n230_n138# pfet_03v3 ad=2.76p pd=6.76u as=1.3p ps=5.3u w=2u l=0.28u
C0 w_n230_n138# a_28_n136# 0.15518f
C1 a_n92_0# a_28_n136# 0.0115f
C2 a_n92_0# w_n230_n138# 0.11176f
C3 a_n92_0# VSUBS 0.06093f
C4 a_28_n136# VSUBS 0.07992f
C5 w_n230_n138# VSUBS 1.54147f
.ends

.subckt comp_pfet$2 a_28_460# a_n92_0# w_n230_n138# VSUBS
X0 w_n230_n138# a_28_460# a_n92_0# w_n230_n138# pfet_03v3 ad=2.76p pd=6.76u as=1.3p ps=5.3u w=2u l=0.28u
C0 w_n230_n138# a_28_460# 0.15518f
C1 a_n92_0# a_28_460# 0.0115f
C2 a_n92_0# w_n230_n138# 0.11176f
C3 a_n92_0# VSUBS 0.06093f
C4 a_28_460# VSUBS 0.07992f
C5 w_n230_n138# VSUBS 1.54147f
.ends

.subckt comp_nfet$5 a_30_n132# a_n84_0# a_94_0#
X0 a_94_0# a_30_n132# a_n84_0# a_94_0# nfet_03v3 ad=7.92p pd=14.64u as=3.66p ps=13.22u w=6u l=0.28u
C0 a_30_n132# a_n84_0# 0.04298f
C1 a_n84_0# a_94_0# 0.61736f
C2 a_30_n132# a_94_0# 0.25799f
.ends

.subckt comp_strongarm_comp_core out_p vin_p vin_n rst_latch out_n vdd vss
Xcomp_nfet_0 out_n vss out_p comp_nfet
Xcomp_pfet$3_0 out_n out_p vdd vss comp_pfet$3
Xcomp_nfet$6_0 vss vss rst_latch comp_nfet$6
Xcomp_pfet$1_0 out_p out_n vdd vss comp_pfet$1
Xcomp_nfet$4_0 vin_p vss vss comp_nfet$4
Xcomp_nfet$2_0 out_n out_p vss comp_nfet$2
Xcomp_pfet_0 rst_latch out_p vdd vss comp_pfet
Xcomp_pfet_1 rst_latch vss vdd vss comp_pfet
Xcomp_pfet$2_0 rst_latch out_n vdd vss comp_pfet$2
Xcomp_pfet$2_1 rst_latch vss vdd vss comp_pfet$2
Xcomp_nfet$5_0 vin_n vss vss comp_nfet$5
C0 out_p vdd 0.91848f
C1 rst_latch vdd 0.71782f
C2 out_n vdd 0.87853f
C3 out_p rst_latch 0.27629f
C4 out_p out_n 1.74679f
C5 rst_latch out_n 0.29061f
C6 vin_p rst_latch 0.01194f
C7 rst_latch vin_n 0.01048f
C8 vdd vss 6.92711f
C9 vin_n vss 0.11539f
C10 out_p vss -0.19167f
C11 out_n vss -0.16122f
C12 vin_p vss 0.1104f
C13 rst_latch vss 1.78684f
.ends

.subckt comp_pfet$5 a_n92_0# a_28_260# w_n230_n138# VSUBS
X0 w_n230_n138# a_28_260# a_n92_0# w_n230_n138# pfet_03v3 ad=1.38p pd=4.76u as=0.65p ps=3.3u w=1u l=0.28u
C0 a_28_260# w_n230_n138# 0.14751f
C1 a_n92_0# w_n230_n138# 0.0352f
C2 a_n92_0# VSUBS 0.03098f
C3 a_28_260# VSUBS 0.08197f
C4 w_n230_n138# VSUBS 1.08986f
.ends

.subckt comp_nfet$8 a_30_n132# a_n84_0# a_94_0#
X0 a_94_0# a_30_n132# a_n84_0# a_94_0# nfet_03v3 ad=0.66p pd=3.64u as=0.305p ps=2.22u w=0.5u l=0.28u
C0 a_n84_0# a_94_0# 0.07023f
C1 a_30_n132# a_94_0# 0.22571f
.ends

.subckt comp_pfet$1$1 a_28_n136# a_n92_0# w_n230_n138# VSUBS
X0 w_n230_n138# a_28_n136# a_n92_0# w_n230_n138# pfet_03v3 ad=1.38p pd=4.76u as=0.65p ps=3.3u w=1u l=0.28u
C0 a_28_n136# w_n230_n138# 0.14751f
C1 a_n92_0# w_n230_n138# 0.0352f
C2 a_n92_0# VSUBS 0.03098f
C3 a_28_n136# VSUBS 0.08197f
C4 w_n230_n138# VSUBS 1.08986f
.ends

.subckt comp_nfet$3 a_n84_0# a_94_0# a_30_160#
X0 a_94_0# a_30_160# a_n84_0# a_94_0# nfet_03v3 ad=0.66p pd=3.64u as=0.305p ps=2.22u w=0.5u l=0.28u
C0 a_n84_0# a_94_0# 0.07023f
C1 a_30_160# a_94_0# 0.22571f
.ends

.subckt comp_async_nand2 input_A input_B output vdd vss
Xcomp_pfet$5_0 output input_A vdd vss comp_pfet$5
Xcomp_nfet$8_0 input_A output vss comp_nfet$8
Xcomp_pfet$1$1_0 input_B output vdd vss comp_pfet$1$1
Xcomp_nfet$3_0 vss vss input_B comp_nfet$3
C0 input_A output 0.2678f
C1 input_B output 0.03318f
C2 vdd input_A 0.02894f
C3 vdd input_B 0.03147f
C4 vdd output 0.37426f
C5 output vss 0.13393f
C6 input_B vss 0.28859f
C7 vdd vss 0.35673f
C8 input_A vss 0.0526f
.ends

.subckt comp_comp_nand_3v3 b y vdd a vss
Xcomp_async_nand2_0 a b y vdd vss comp_async_nand2
C0 y vss -0.24916f
C1 b vss -0.14653f
C2 vdd vss -0.42086f
C3 a vss -0.14203f
.ends

.subckt comp_comp_xor_fast a b y comp_comp_nand_3v3_3/b comp_comp_nand_3v3_2/b vdd
+ comp_comp_nand_3v3_3/a vss
Xcomp_comp_nand_3v3_1 b comp_comp_nand_3v3_2/b vdd a vss comp_comp_nand_3v3
Xcomp_comp_nand_3v3_2 comp_comp_nand_3v3_2/b comp_comp_nand_3v3_3/b vdd b vss comp_comp_nand_3v3
Xcomp_comp_nand_3v3_3 comp_comp_nand_3v3_3/b y vdd comp_comp_nand_3v3_3/a vss comp_comp_nand_3v3
Xcomp_comp_nand_3v3_0 comp_comp_nand_3v3_2/b comp_comp_nand_3v3_3/a vdd a vss comp_comp_nand_3v3
C0 comp_comp_nand_3v3_2/b comp_comp_nand_3v3_3/b 0.2078f
C1 comp_comp_nand_3v3_3/a vdd 0.17953f
C2 a b 0.10918f
C3 comp_comp_nand_3v3_2/b b 0.2062f
C4 comp_comp_nand_3v3_3/a comp_comp_nand_3v3_3/b 0.02481f
C5 comp_comp_nand_3v3_3/b vdd 0.06158f
C6 comp_comp_nand_3v3_2/b a 0.13072f
C7 y comp_comp_nand_3v3_3/a 0.02873f
C8 y vdd 0.06672f
C9 y comp_comp_nand_3v3_3/b 0.09745f
C10 vdd b 0.15822f
C11 comp_comp_nand_3v3_3/a a 0.01214f
C12 a vdd 0.32018f
C13 comp_comp_nand_3v3_2/b comp_comp_nand_3v3_3/a 0.19722f
C14 comp_comp_nand_3v3_2/b vdd 0.3953f
C15 comp_comp_nand_3v3_3/b b 0.01016f
C16 comp_comp_nand_3v3_3/a vss 0.05417f
C17 a vss 0.45866f
C18 y vss 0.04072f
C19 comp_comp_nand_3v3_3/b vss 0.44242f
C20 comp_comp_nand_3v3_2/b vss 0.24244f
C21 b vss 0.75623f
C22 vdd vss 0.1906f
.ends

.subckt strongarm_comp comp_done out_p out_n vin_p vin_n rst_latch comp_comp_xor_fast_0/comp_comp_nand_3v3_2/b
+ comp_comp_inv_3v3_1/vi comp_comp_xor_fast_0/comp_comp_nand_3v3_3/a comp_comp_xor_fast_0/comp_comp_nand_3v3_3/b
+ comp_comp_inv_3v3_0/vi vdd vss
Xcomp_comp_inv_3v3_0 comp_comp_inv_3v3_0/vi vdd vss out_n comp_comp_inv_3v3
Xcomp_strongarm_comp_core_0 comp_comp_inv_3v3_1/vi vin_p vin_n rst_latch comp_comp_inv_3v3_0/vi
+ vdd vss comp_strongarm_comp_core
Xcomp_comp_inv_3v3_1 comp_comp_inv_3v3_1/vi vdd vss out_p comp_comp_inv_3v3
Xcomp_comp_xor_fast_0 out_p out_n comp_done comp_comp_xor_fast_0/comp_comp_nand_3v3_3/b
+ comp_comp_xor_fast_0/comp_comp_nand_3v3_2/b vdd comp_comp_xor_fast_0/comp_comp_nand_3v3_3/a
+ vss comp_comp_xor_fast
C0 vin_n rst_latch 0.13866f
C1 vin_p comp_comp_inv_3v3_0/vi 0.01611f
C2 comp_comp_inv_3v3_1/vi rst_latch 0.0777f
C3 comp_comp_xor_fast_0/comp_comp_nand_3v3_2/b out_n 0.01051f
C4 vdd rst_latch 0.02917f
C5 out_n comp_comp_inv_3v3_0/vi 0.02416f
C6 comp_comp_inv_3v3_1/vi vdd 0.44101f
C7 comp_comp_inv_3v3_1/vi out_p 0.05296f
C8 comp_done vdd 0.11749f
C9 vin_p rst_latch 0.14893f
C10 out_p vdd 0.49394f
C11 comp_comp_xor_fast_0/comp_comp_nand_3v3_3/a comp_done 0.03205f
C12 vin_n comp_comp_inv_3v3_0/vi 0.05824f
C13 comp_comp_inv_3v3_0/vi rst_latch 0.14396f
C14 out_n vdd 0.56471f
C15 out_n out_p 0.63127f
C16 comp_comp_inv_3v3_1/vi comp_comp_inv_3v3_0/vi 0.18332f
C17 vdd comp_comp_inv_3v3_0/vi 0.09109f
C18 comp_comp_xor_fast_0/comp_comp_nand_3v3_3/a vss -0.70892f
C19 out_p vss -0.95703f
C20 comp_done vss -0.10944f
C21 comp_comp_xor_fast_0/comp_comp_nand_3v3_3/b vss -0.63744f
C22 comp_comp_xor_fast_0/comp_comp_nand_3v3_2/b vss -1.02635f
C23 out_n vss -0.63296f
C24 vdd vss -11.33105f
C25 vin_n vss 0.35979f
C26 comp_comp_inv_3v3_1/vi vss -0.12278f
C27 comp_comp_inv_3v3_0/vi vss 0.70743f
C28 vin_p vss 0.47379f
C29 rst_latch vss -0.61316f
.ends

.subckt cdac_nfet a_254_0# a_30_n132# a_n84_0# a_94_0# a_190_n132#
X0 a_254_0# a_190_n132# a_94_0# a_254_0# nfet_03v3 ad=5.28p pd=10.64u as=1.04p ps=4.52u w=4u l=0.28u
X1 a_94_0# a_30_n132# a_n84_0# a_254_0# nfet_03v3 ad=1.04p pd=4.52u as=2.44p ps=9.22u w=4u l=0.28u
C0 a_n84_0# a_30_n132# 0.02741f
C1 a_190_n132# a_94_0# 0.02942f
C2 a_94_0# a_30_n132# 0.02942f
C3 a_190_n132# a_30_n132# 0.0661f
C4 a_n84_0# a_94_0# 0.28823f
C5 a_94_0# a_254_0# 0.3151f
C6 a_n84_0# a_254_0# 0.1615f
C7 a_190_n132# a_254_0# 0.2076f
C8 a_30_n132# a_254_0# 0.18019f
.ends

.subckt cdac_pfet a_254_0# a_348_860# a_414_0# a_n92_0# a_94_0# a_508_860# a_188_860#
+ a_28_860# w_n230_n138# VSUBS
X0 a_254_0# a_188_860# a_94_0# w_n230_n138# pfet_03v3 ad=1.04p pd=4.52u as=1.04p ps=4.52u w=4u l=0.28u
X1 w_n230_n138# a_508_860# a_414_0# w_n230_n138# pfet_03v3 ad=5.52p pd=10.76u as=1.04p ps=4.52u w=4u l=0.28u
X2 a_94_0# a_28_860# a_n92_0# w_n230_n138# pfet_03v3 ad=1.04p pd=4.52u as=2.6p ps=9.3u w=4u l=0.28u
X3 a_414_0# a_348_860# a_254_0# w_n230_n138# pfet_03v3 ad=1.04p pd=4.52u as=1.04p ps=4.52u w=4u l=0.28u
C0 a_188_860# a_254_0# 0.02941f
C1 a_28_860# a_188_860# 0.06717f
C2 a_188_860# a_94_0# 0.02941f
C3 a_348_860# a_254_0# 0.02941f
C4 a_188_860# w_n230_n138# 0.10299f
C5 a_n92_0# a_28_860# 0.02707f
C6 a_348_860# w_n230_n138# 0.10299f
C7 a_508_860# w_n230_n138# 0.15313f
C8 a_n92_0# a_94_0# 0.27893f
C9 a_n92_0# w_n230_n138# 0.03964f
C10 a_414_0# a_348_860# 0.02941f
C11 a_414_0# a_508_860# 0.02941f
C12 a_94_0# a_254_0# 0.38435f
C13 a_28_860# a_94_0# 0.02941f
C14 a_28_860# w_n230_n138# 0.12037f
C15 a_188_860# a_348_860# 0.06717f
C16 a_414_0# a_254_0# 0.38435f
C17 a_508_860# a_348_860# 0.06717f
C18 a_414_0# w_n230_n138# 0.28569f
C19 a_414_0# VSUBS 0.02011f
C20 a_254_0# VSUBS 0.02011f
C21 a_94_0# VSUBS 0.02011f
C22 a_n92_0# VSUBS 0.12084f
C23 a_508_860# VSUBS 0.05868f
C24 a_348_860# VSUBS 0.04513f
C25 a_188_860# VSUBS 0.04513f
C26 a_28_860# VSUBS 0.06437f
C27 w_n230_n138# VSUBS 4.00118f
.ends

.subckt cdac_nfet$3 a_734_0# a_510_n132# a_254_0# a_894_0# a_670_n132# a_830_n132#
+ a_414_0# a_30_n132# a_n84_0# a_94_0# a_190_n132# a_574_0# a_350_n132#
X0 a_734_0# a_670_n132# a_574_0# a_894_0# nfet_03v3 ad=1.04p pd=4.52u as=1.04p ps=4.52u w=4u l=0.28u
X1 a_254_0# a_190_n132# a_94_0# a_894_0# nfet_03v3 ad=1.04p pd=4.52u as=1.04p ps=4.52u w=4u l=0.28u
X2 a_574_0# a_510_n132# a_414_0# a_894_0# nfet_03v3 ad=1.04p pd=4.52u as=1.04p ps=4.52u w=4u l=0.28u
X3 a_894_0# a_830_n132# a_734_0# a_894_0# nfet_03v3 ad=5.28p pd=10.64u as=1.04p ps=4.52u w=4u l=0.28u
X4 a_94_0# a_30_n132# a_n84_0# a_894_0# nfet_03v3 ad=1.04p pd=4.52u as=2.44p ps=9.22u w=4u l=0.28u
X5 a_414_0# a_350_n132# a_254_0# a_894_0# nfet_03v3 ad=1.04p pd=4.52u as=1.04p ps=4.52u w=4u l=0.28u
C0 a_254_0# a_350_n132# 0.02942f
C1 a_190_n132# a_254_0# 0.02942f
C2 a_510_n132# a_574_0# 0.02942f
C3 a_254_0# a_94_0# 0.38435f
C4 a_670_n132# a_830_n132# 0.0661f
C5 a_190_n132# a_30_n132# 0.0661f
C6 a_190_n132# a_350_n132# 0.0661f
C7 a_30_n132# a_94_0# 0.02942f
C8 a_254_0# a_414_0# 0.38435f
C9 a_670_n132# a_574_0# 0.02942f
C10 a_190_n132# a_94_0# 0.02942f
C11 a_350_n132# a_414_0# 0.02942f
C12 a_734_0# a_830_n132# 0.02942f
C13 a_670_n132# a_510_n132# 0.0661f
C14 a_734_0# a_574_0# 0.38435f
C15 a_30_n132# a_n84_0# 0.02741f
C16 a_734_0# a_670_n132# 0.02942f
C17 a_n84_0# a_94_0# 0.28823f
C18 a_350_n132# a_510_n132# 0.0661f
C19 a_414_0# a_574_0# 0.38435f
C20 a_510_n132# a_414_0# 0.02942f
C21 a_734_0# a_894_0# 0.3151f
C22 a_574_0# a_894_0# 0.02686f
C23 a_414_0# a_894_0# 0.02686f
C24 a_254_0# a_894_0# 0.02686f
C25 a_94_0# a_894_0# 0.02686f
C26 a_n84_0# a_894_0# 0.1615f
C27 a_830_n132# a_894_0# 0.2076f
C28 a_670_n132# a_894_0# 0.14437f
C29 a_510_n132# a_894_0# 0.14437f
C30 a_350_n132# a_894_0# 0.14437f
C31 a_190_n132# a_894_0# 0.14437f
C32 a_30_n132# a_894_0# 0.18019f
.ends

.subckt cdac_pfet$3 a_1054_0# a_734_0# a_254_0# a_894_0# a_348_860# a_828_860# a_988_860#
+ a_414_0# a_n92_0# a_94_0# a_574_0# a_508_860# a_188_860# a_668_860# a_1148_860#
+ a_28_860# w_n230_n138# VSUBS
X0 w_n230_n138# a_1148_860# a_1054_0# w_n230_n138# pfet_03v3 ad=5.52p pd=10.76u as=1.04p ps=4.52u w=4u l=0.28u
X1 a_734_0# a_668_860# a_574_0# w_n230_n138# pfet_03v3 ad=1.04p pd=4.52u as=1.04p ps=4.52u w=4u l=0.28u
X2 a_254_0# a_188_860# a_94_0# w_n230_n138# pfet_03v3 ad=1.04p pd=4.52u as=1.04p ps=4.52u w=4u l=0.28u
X3 a_574_0# a_508_860# a_414_0# w_n230_n138# pfet_03v3 ad=1.04p pd=4.52u as=1.04p ps=4.52u w=4u l=0.28u
X4 a_1054_0# a_988_860# a_894_0# w_n230_n138# pfet_03v3 ad=1.04p pd=4.52u as=1.04p ps=4.52u w=4u l=0.28u
X5 a_894_0# a_828_860# a_734_0# w_n230_n138# pfet_03v3 ad=1.04p pd=4.52u as=1.04p ps=4.52u w=4u l=0.28u
X6 a_94_0# a_28_860# a_n92_0# w_n230_n138# pfet_03v3 ad=1.04p pd=4.52u as=2.6p ps=9.3u w=4u l=0.28u
X7 a_414_0# a_348_860# a_254_0# w_n230_n138# pfet_03v3 ad=1.04p pd=4.52u as=1.04p ps=4.52u w=4u l=0.28u
C0 a_254_0# a_94_0# 0.38435f
C1 a_94_0# a_188_860# 0.02941f
C2 a_894_0# a_734_0# 0.38435f
C3 a_988_860# a_1148_860# 0.06717f
C4 a_414_0# a_508_860# 0.02941f
C5 a_254_0# a_188_860# 0.02941f
C6 a_668_860# a_828_860# 0.06717f
C7 w_n230_n138# a_1054_0# 0.28569f
C8 a_668_860# a_574_0# 0.02941f
C9 a_348_860# a_508_860# 0.06717f
C10 a_894_0# a_1054_0# 0.38435f
C11 w_n230_n138# a_28_860# 0.12037f
C12 w_n230_n138# a_508_860# 0.10299f
C13 a_988_860# a_828_860# 0.06717f
C14 w_n230_n138# a_1148_860# 0.15313f
C15 a_254_0# a_414_0# 0.38435f
C16 a_414_0# a_574_0# 0.38435f
C17 a_1054_0# a_1148_860# 0.02941f
C18 a_828_860# a_734_0# 0.02941f
C19 a_254_0# a_348_860# 0.02941f
C20 a_734_0# a_574_0# 0.38435f
C21 a_348_860# a_188_860# 0.06717f
C22 w_n230_n138# a_n92_0# 0.03964f
C23 a_668_860# a_734_0# 0.02941f
C24 w_n230_n138# a_828_860# 0.10299f
C25 w_n230_n138# a_188_860# 0.10299f
C26 a_894_0# a_828_860# 0.02941f
C27 a_668_860# w_n230_n138# 0.10299f
C28 a_n92_0# a_28_860# 0.02707f
C29 a_94_0# a_28_860# 0.02941f
C30 a_348_860# a_414_0# 0.02941f
C31 a_28_860# a_188_860# 0.06717f
C32 a_574_0# a_508_860# 0.02941f
C33 w_n230_n138# a_988_860# 0.10299f
C34 a_668_860# a_508_860# 0.06717f
C35 a_1054_0# a_988_860# 0.02941f
C36 a_94_0# a_n92_0# 0.27893f
C37 a_894_0# a_988_860# 0.02941f
C38 w_n230_n138# a_348_860# 0.10299f
C39 a_1054_0# VSUBS 0.02011f
C40 a_894_0# VSUBS 0.02011f
C41 a_734_0# VSUBS 0.02011f
C42 a_574_0# VSUBS 0.02011f
C43 a_414_0# VSUBS 0.02011f
C44 a_254_0# VSUBS 0.02011f
C45 a_94_0# VSUBS 0.02011f
C46 a_n92_0# VSUBS 0.12084f
C47 a_1148_860# VSUBS 0.05868f
C48 a_988_860# VSUBS 0.04513f
C49 a_828_860# VSUBS 0.04513f
C50 a_668_860# VSUBS 0.04513f
C51 a_508_860# VSUBS 0.04513f
C52 a_348_860# VSUBS 0.04513f
C53 a_188_860# VSUBS 0.04513f
C54 a_28_860# VSUBS 0.06437f
C55 w_n230_n138# VSUBS 6.0671f
.ends

.subckt cdac_cdac_switch_1b bit_b vdd bot bit vss
Xcdac_nfet_0 vss bit vss bit_b bit cdac_nfet
Xcdac_pfet_0 vdd bit bit_b vdd bit_b bit bit bit vdd vss cdac_pfet
Xcdac_nfet$3_0 bot bit_b vss vss bit_b bit_b bot bit_b vss bot bit_b vss bit_b cdac_nfet$3
Xcdac_pfet$3_0 bot bot vdd vdd bit_b bit_b bit_b bot vdd bot vdd bit_b bit_b bit_b
+ bit_b bit_b vdd vss cdac_pfet$3
C0 vdd bit_b 0.65186f
C1 vdd bot 0.46186f
C2 bit bit_b 0.19536f
C3 bit bot 0.0129f
C4 bit_b bot 0.70867f
C5 bit vdd 0.22529f
C6 bot vss 1.13962f
C7 vdd vss 5.90196f
C8 bit_b vss 0.854f
C9 bit vss 1.18895f
.ends

.subckt cdac_cap_mim m4_n120_n120# m4_0_0# VSUBS
X0 m4_0_0# m4_n120_n120# cap_mim_2f0_m4m5_noshield c_width=5u c_length=5u
C0 m4_n120_n120# m4_0_0# 0.29597f
C1 m4_0_0# VSUBS 0.7709f
C2 m4_n120_n120# VSUBS 0.80036f
.ends

.subckt cdac_8bit bot6 bot5 bot4 bot3 bot2 bot1 bot0 vdd vdac dac_in[0] dac_in[7]
+ dac_in[6] dac_in[5] dac_in[4] dac_in[1] dac_in[2] cdac_cdac_switch_1b_1/bit_b bot7
+ cdac_cdac_switch_1b_2/bit_b cdac_cdac_switch_1b_3/bit_b vref dac_in[3] vss
Xcdac_cdac_switch_1b_0 cdac_cdac_switch_1b_0/bit_b vref bot0 dac_in[0] vss cdac_cdac_switch_1b
Xcdac_cdac_switch_1b_1 cdac_cdac_switch_1b_1/bit_b vref bot1 dac_in[1] vss cdac_cdac_switch_1b
Xcdac_cdac_switch_1b_2 cdac_cdac_switch_1b_2/bit_b vref bot2 dac_in[2] vss cdac_cdac_switch_1b
Xcdac_cdac_switch_1b_3 cdac_cdac_switch_1b_3/bit_b vref bot3 dac_in[3] vss cdac_cdac_switch_1b
Xcdac_cdac_switch_1b_4 cdac_cdac_switch_1b_4/bit_b vref bot5 dac_in[5] vss cdac_cdac_switch_1b
Xcdac_cap_mim_0[0|0] vdac bot7 vss cdac_cap_mim
Xcdac_cap_mim_0[1|0] vdac bot7 vss cdac_cap_mim
Xcdac_cap_mim_0[2|0] vdac bot7 vss cdac_cap_mim
Xcdac_cap_mim_0[3|0] vdac bot7 vss cdac_cap_mim
Xcdac_cap_mim_0[4|0] vdac bot7 vss cdac_cap_mim
Xcdac_cap_mim_0[5|0] vdac bot7 vss cdac_cap_mim
Xcdac_cap_mim_0[6|0] vdac bot7 vss cdac_cap_mim
Xcdac_cap_mim_0[7|0] vdac bot7 vss cdac_cap_mim
Xcdac_cap_mim_0[8|0] vdac bot7 vss cdac_cap_mim
Xcdac_cap_mim_0[9|0] vdac bot7 vss cdac_cap_mim
Xcdac_cap_mim_0[10|0] vdac bot7 vss cdac_cap_mim
Xcdac_cap_mim_0[11|0] vdac bot7 vss cdac_cap_mim
Xcdac_cap_mim_0[12|0] vdac bot7 vss cdac_cap_mim
Xcdac_cap_mim_0[13|0] vdac bot7 vss cdac_cap_mim
Xcdac_cap_mim_0[14|0] vdac bot7 vss cdac_cap_mim
Xcdac_cap_mim_0[15|0] vdac bot7 vss cdac_cap_mim
Xcdac_cap_mim_0[0|1] vdac bot7 vss cdac_cap_mim
Xcdac_cap_mim_0[1|1] vdac bot7 vss cdac_cap_mim
Xcdac_cap_mim_0[2|1] vdac bot7 vss cdac_cap_mim
Xcdac_cap_mim_0[3|1] vdac bot7 vss cdac_cap_mim
Xcdac_cap_mim_0[4|1] vdac bot7 vss cdac_cap_mim
Xcdac_cap_mim_0[5|1] vdac bot7 vss cdac_cap_mim
Xcdac_cap_mim_0[6|1] vdac bot7 vss cdac_cap_mim
Xcdac_cap_mim_0[7|1] vdac bot7 vss cdac_cap_mim
Xcdac_cap_mim_0[8|1] vdac bot7 vss cdac_cap_mim
Xcdac_cap_mim_0[9|1] vdac bot7 vss cdac_cap_mim
Xcdac_cap_mim_0[10|1] vdac bot7 vss cdac_cap_mim
Xcdac_cap_mim_0[11|1] vdac bot7 vss cdac_cap_mim
Xcdac_cap_mim_0[12|1] vdac bot7 vss cdac_cap_mim
Xcdac_cap_mim_0[13|1] vdac bot7 vss cdac_cap_mim
Xcdac_cap_mim_0[14|1] vdac bot7 vss cdac_cap_mim
Xcdac_cap_mim_0[15|1] vdac bot7 vss cdac_cap_mim
Xcdac_cap_mim_0[0|2] vdac bot7 vss cdac_cap_mim
Xcdac_cap_mim_0[1|2] vdac bot7 vss cdac_cap_mim
Xcdac_cap_mim_0[2|2] vdac bot7 vss cdac_cap_mim
Xcdac_cap_mim_0[3|2] vdac bot7 vss cdac_cap_mim
Xcdac_cap_mim_0[4|2] vdac bot7 vss cdac_cap_mim
Xcdac_cap_mim_0[5|2] vdac bot7 vss cdac_cap_mim
Xcdac_cap_mim_0[6|2] vdac bot7 vss cdac_cap_mim
Xcdac_cap_mim_0[7|2] vdac bot7 vss cdac_cap_mim
Xcdac_cap_mim_0[8|2] vdac bot7 vss cdac_cap_mim
Xcdac_cap_mim_0[9|2] vdac bot7 vss cdac_cap_mim
Xcdac_cap_mim_0[10|2] vdac bot7 vss cdac_cap_mim
Xcdac_cap_mim_0[11|2] vdac bot7 vss cdac_cap_mim
Xcdac_cap_mim_0[12|2] vdac bot7 vss cdac_cap_mim
Xcdac_cap_mim_0[13|2] vdac bot7 vss cdac_cap_mim
Xcdac_cap_mim_0[14|2] vdac bot7 vss cdac_cap_mim
Xcdac_cap_mim_0[15|2] vdac bot7 vss cdac_cap_mim
Xcdac_cap_mim_0[0|3] vdac bot7 vss cdac_cap_mim
Xcdac_cap_mim_0[1|3] vdac bot7 vss cdac_cap_mim
Xcdac_cap_mim_0[2|3] vdac bot7 vss cdac_cap_mim
Xcdac_cap_mim_0[3|3] vdac bot7 vss cdac_cap_mim
Xcdac_cap_mim_0[4|3] vdac bot7 vss cdac_cap_mim
Xcdac_cap_mim_0[5|3] vdac bot7 vss cdac_cap_mim
Xcdac_cap_mim_0[6|3] vdac bot7 vss cdac_cap_mim
Xcdac_cap_mim_0[7|3] vdac bot7 vss cdac_cap_mim
Xcdac_cap_mim_0[8|3] vdac bot7 vss cdac_cap_mim
Xcdac_cap_mim_0[9|3] vdac bot7 vss cdac_cap_mim
Xcdac_cap_mim_0[10|3] vdac bot7 vss cdac_cap_mim
Xcdac_cap_mim_0[11|3] vdac bot7 vss cdac_cap_mim
Xcdac_cap_mim_0[12|3] vdac bot7 vss cdac_cap_mim
Xcdac_cap_mim_0[13|3] vdac bot7 vss cdac_cap_mim
Xcdac_cap_mim_0[14|3] vdac bot7 vss cdac_cap_mim
Xcdac_cap_mim_0[15|3] vdac bot7 vss cdac_cap_mim
Xcdac_cap_mim_0[0|4] vdac bot7 vss cdac_cap_mim
Xcdac_cap_mim_0[1|4] vdac bot7 vss cdac_cap_mim
Xcdac_cap_mim_0[2|4] vdac bot7 vss cdac_cap_mim
Xcdac_cap_mim_0[3|4] vdac bot7 vss cdac_cap_mim
Xcdac_cap_mim_0[4|4] vdac bot7 vss cdac_cap_mim
Xcdac_cap_mim_0[5|4] vdac bot7 vss cdac_cap_mim
Xcdac_cap_mim_0[6|4] vdac bot7 vss cdac_cap_mim
Xcdac_cap_mim_0[7|4] vdac bot7 vss cdac_cap_mim
Xcdac_cap_mim_0[8|4] vdac bot7 vss cdac_cap_mim
Xcdac_cap_mim_0[9|4] vdac bot7 vss cdac_cap_mim
Xcdac_cap_mim_0[10|4] vdac bot7 vss cdac_cap_mim
Xcdac_cap_mim_0[11|4] vdac bot7 vss cdac_cap_mim
Xcdac_cap_mim_0[12|4] vdac bot7 vss cdac_cap_mim
Xcdac_cap_mim_0[13|4] vdac bot7 vss cdac_cap_mim
Xcdac_cap_mim_0[14|4] vdac bot7 vss cdac_cap_mim
Xcdac_cap_mim_0[15|4] vdac bot7 vss cdac_cap_mim
Xcdac_cap_mim_0[0|5] vdac bot7 vss cdac_cap_mim
Xcdac_cap_mim_0[1|5] vdac bot7 vss cdac_cap_mim
Xcdac_cap_mim_0[2|5] vdac bot7 vss cdac_cap_mim
Xcdac_cap_mim_0[3|5] vdac bot7 vss cdac_cap_mim
Xcdac_cap_mim_0[4|5] vdac bot7 vss cdac_cap_mim
Xcdac_cap_mim_0[5|5] vdac bot7 vss cdac_cap_mim
Xcdac_cap_mim_0[6|5] vdac bot7 vss cdac_cap_mim
Xcdac_cap_mim_0[7|5] vdac bot7 vss cdac_cap_mim
Xcdac_cap_mim_0[8|5] vdac bot7 vss cdac_cap_mim
Xcdac_cap_mim_0[9|5] vdac bot7 vss cdac_cap_mim
Xcdac_cap_mim_0[10|5] vdac bot7 vss cdac_cap_mim
Xcdac_cap_mim_0[11|5] vdac bot7 vss cdac_cap_mim
Xcdac_cap_mim_0[12|5] vdac bot7 vss cdac_cap_mim
Xcdac_cap_mim_0[13|5] vdac bot7 vss cdac_cap_mim
Xcdac_cap_mim_0[14|5] vdac bot7 vss cdac_cap_mim
Xcdac_cap_mim_0[15|5] vdac bot7 vss cdac_cap_mim
Xcdac_cap_mim_0[0|6] vdac bot7 vss cdac_cap_mim
Xcdac_cap_mim_0[1|6] vdac bot7 vss cdac_cap_mim
Xcdac_cap_mim_0[2|6] vdac bot7 vss cdac_cap_mim
Xcdac_cap_mim_0[3|6] vdac bot7 vss cdac_cap_mim
Xcdac_cap_mim_0[4|6] vdac bot7 vss cdac_cap_mim
Xcdac_cap_mim_0[5|6] vdac bot7 vss cdac_cap_mim
Xcdac_cap_mim_0[6|6] vdac bot7 vss cdac_cap_mim
Xcdac_cap_mim_0[7|6] vdac bot7 vss cdac_cap_mim
Xcdac_cap_mim_0[8|6] vdac bot7 vss cdac_cap_mim
Xcdac_cap_mim_0[9|6] vdac bot7 vss cdac_cap_mim
Xcdac_cap_mim_0[10|6] vdac bot7 vss cdac_cap_mim
Xcdac_cap_mim_0[11|6] vdac bot7 vss cdac_cap_mim
Xcdac_cap_mim_0[12|6] vdac bot7 vss cdac_cap_mim
Xcdac_cap_mim_0[13|6] vdac bot7 vss cdac_cap_mim
Xcdac_cap_mim_0[14|6] vdac bot7 vss cdac_cap_mim
Xcdac_cap_mim_0[15|6] vdac bot7 vss cdac_cap_mim
Xcdac_cap_mim_0[0|7] vdac bot7 vss cdac_cap_mim
Xcdac_cap_mim_0[1|7] vdac bot7 vss cdac_cap_mim
Xcdac_cap_mim_0[2|7] vdac bot7 vss cdac_cap_mim
Xcdac_cap_mim_0[3|7] vdac bot7 vss cdac_cap_mim
Xcdac_cap_mim_0[4|7] vdac bot7 vss cdac_cap_mim
Xcdac_cap_mim_0[5|7] vdac bot7 vss cdac_cap_mim
Xcdac_cap_mim_0[6|7] vdac bot7 vss cdac_cap_mim
Xcdac_cap_mim_0[7|7] vdac bot7 vss cdac_cap_mim
Xcdac_cap_mim_0[8|7] vdac bot7 vss cdac_cap_mim
Xcdac_cap_mim_0[9|7] vdac bot7 vss cdac_cap_mim
Xcdac_cap_mim_0[10|7] vdac bot7 vss cdac_cap_mim
Xcdac_cap_mim_0[11|7] vdac bot7 vss cdac_cap_mim
Xcdac_cap_mim_0[12|7] vdac bot7 vss cdac_cap_mim
Xcdac_cap_mim_0[13|7] vdac bot7 vss cdac_cap_mim
Xcdac_cap_mim_0[14|7] vdac bot7 vss cdac_cap_mim
Xcdac_cap_mim_0[15|7] vdac bot7 vss cdac_cap_mim
Xcdac_cap_mim_0[0|8] vdac bot6 vss cdac_cap_mim
Xcdac_cap_mim_0[1|8] vdac bot6 vss cdac_cap_mim
Xcdac_cap_mim_0[2|8] vdac bot6 vss cdac_cap_mim
Xcdac_cap_mim_0[3|8] vdac bot6 vss cdac_cap_mim
Xcdac_cap_mim_0[4|8] vdac bot6 vss cdac_cap_mim
Xcdac_cap_mim_0[5|8] vdac bot6 vss cdac_cap_mim
Xcdac_cap_mim_0[6|8] vdac bot6 vss cdac_cap_mim
Xcdac_cap_mim_0[7|8] vdac bot6 vss cdac_cap_mim
Xcdac_cap_mim_0[8|8] vdac bot6 vss cdac_cap_mim
Xcdac_cap_mim_0[9|8] vdac bot6 vss cdac_cap_mim
Xcdac_cap_mim_0[10|8] vdac bot6 vss cdac_cap_mim
Xcdac_cap_mim_0[11|8] vdac bot6 vss cdac_cap_mim
Xcdac_cap_mim_0[12|8] vdac bot6 vss cdac_cap_mim
Xcdac_cap_mim_0[13|8] vdac bot6 vss cdac_cap_mim
Xcdac_cap_mim_0[14|8] vdac bot6 vss cdac_cap_mim
Xcdac_cap_mim_0[15|8] vdac bot6 vss cdac_cap_mim
Xcdac_cap_mim_0[0|9] vdac bot6 vss cdac_cap_mim
Xcdac_cap_mim_0[1|9] vdac bot6 vss cdac_cap_mim
Xcdac_cap_mim_0[2|9] vdac bot6 vss cdac_cap_mim
Xcdac_cap_mim_0[3|9] vdac bot6 vss cdac_cap_mim
Xcdac_cap_mim_0[4|9] vdac bot6 vss cdac_cap_mim
Xcdac_cap_mim_0[5|9] vdac bot6 vss cdac_cap_mim
Xcdac_cap_mim_0[6|9] vdac bot6 vss cdac_cap_mim
Xcdac_cap_mim_0[7|9] vdac bot6 vss cdac_cap_mim
Xcdac_cap_mim_0[8|9] vdac bot6 vss cdac_cap_mim
Xcdac_cap_mim_0[9|9] vdac bot6 vss cdac_cap_mim
Xcdac_cap_mim_0[10|9] vdac bot6 vss cdac_cap_mim
Xcdac_cap_mim_0[11|9] vdac bot6 vss cdac_cap_mim
Xcdac_cap_mim_0[12|9] vdac bot6 vss cdac_cap_mim
Xcdac_cap_mim_0[13|9] vdac bot6 vss cdac_cap_mim
Xcdac_cap_mim_0[14|9] vdac bot6 vss cdac_cap_mim
Xcdac_cap_mim_0[15|9] vdac bot6 vss cdac_cap_mim
Xcdac_cap_mim_0[0|10] vdac bot6 vss cdac_cap_mim
Xcdac_cap_mim_0[1|10] vdac bot6 vss cdac_cap_mim
Xcdac_cap_mim_0[2|10] vdac bot6 vss cdac_cap_mim
Xcdac_cap_mim_0[3|10] vdac bot6 vss cdac_cap_mim
Xcdac_cap_mim_0[4|10] vdac bot6 vss cdac_cap_mim
Xcdac_cap_mim_0[5|10] vdac bot6 vss cdac_cap_mim
Xcdac_cap_mim_0[6|10] vdac bot6 vss cdac_cap_mim
Xcdac_cap_mim_0[7|10] vdac bot6 vss cdac_cap_mim
Xcdac_cap_mim_0[8|10] vdac bot6 vss cdac_cap_mim
Xcdac_cap_mim_0[9|10] vdac bot6 vss cdac_cap_mim
Xcdac_cap_mim_0[10|10] vdac bot6 vss cdac_cap_mim
Xcdac_cap_mim_0[11|10] vdac bot6 vss cdac_cap_mim
Xcdac_cap_mim_0[12|10] vdac bot6 vss cdac_cap_mim
Xcdac_cap_mim_0[13|10] vdac bot6 vss cdac_cap_mim
Xcdac_cap_mim_0[14|10] vdac bot6 vss cdac_cap_mim
Xcdac_cap_mim_0[15|10] vdac bot6 vss cdac_cap_mim
Xcdac_cap_mim_0[0|11] vdac bot6 vss cdac_cap_mim
Xcdac_cap_mim_0[1|11] vdac bot6 vss cdac_cap_mim
Xcdac_cap_mim_0[2|11] vdac bot6 vss cdac_cap_mim
Xcdac_cap_mim_0[3|11] vdac bot6 vss cdac_cap_mim
Xcdac_cap_mim_0[4|11] vdac bot6 vss cdac_cap_mim
Xcdac_cap_mim_0[5|11] vdac bot6 vss cdac_cap_mim
Xcdac_cap_mim_0[6|11] vdac bot6 vss cdac_cap_mim
Xcdac_cap_mim_0[7|11] vdac bot6 vss cdac_cap_mim
Xcdac_cap_mim_0[8|11] vdac bot6 vss cdac_cap_mim
Xcdac_cap_mim_0[9|11] vdac bot6 vss cdac_cap_mim
Xcdac_cap_mim_0[10|11] vdac bot6 vss cdac_cap_mim
Xcdac_cap_mim_0[11|11] vdac bot6 vss cdac_cap_mim
Xcdac_cap_mim_0[12|11] vdac bot6 vss cdac_cap_mim
Xcdac_cap_mim_0[13|11] vdac bot6 vss cdac_cap_mim
Xcdac_cap_mim_0[14|11] vdac bot6 vss cdac_cap_mim
Xcdac_cap_mim_0[15|11] vdac bot6 vss cdac_cap_mim
Xcdac_cap_mim_0[0|12] vdac bot5 vss cdac_cap_mim
Xcdac_cap_mim_0[1|12] vdac bot5 vss cdac_cap_mim
Xcdac_cap_mim_0[2|12] vdac bot5 vss cdac_cap_mim
Xcdac_cap_mim_0[3|12] vdac bot5 vss cdac_cap_mim
Xcdac_cap_mim_0[4|12] vdac bot5 vss cdac_cap_mim
Xcdac_cap_mim_0[5|12] vdac bot5 vss cdac_cap_mim
Xcdac_cap_mim_0[6|12] vdac bot5 vss cdac_cap_mim
Xcdac_cap_mim_0[7|12] vdac bot5 vss cdac_cap_mim
Xcdac_cap_mim_0[8|12] vdac bot5 vss cdac_cap_mim
Xcdac_cap_mim_0[9|12] vdac bot5 vss cdac_cap_mim
Xcdac_cap_mim_0[10|12] vdac bot5 vss cdac_cap_mim
Xcdac_cap_mim_0[11|12] vdac bot5 vss cdac_cap_mim
Xcdac_cap_mim_0[12|12] vdac bot5 vss cdac_cap_mim
Xcdac_cap_mim_0[13|12] vdac bot5 vss cdac_cap_mim
Xcdac_cap_mim_0[14|12] vdac bot5 vss cdac_cap_mim
Xcdac_cap_mim_0[15|12] vdac bot5 vss cdac_cap_mim
Xcdac_cap_mim_0[0|13] vdac bot5 vss cdac_cap_mim
Xcdac_cap_mim_0[1|13] vdac bot5 vss cdac_cap_mim
Xcdac_cap_mim_0[2|13] vdac bot5 vss cdac_cap_mim
Xcdac_cap_mim_0[3|13] vdac bot5 vss cdac_cap_mim
Xcdac_cap_mim_0[4|13] vdac bot5 vss cdac_cap_mim
Xcdac_cap_mim_0[5|13] vdac bot5 vss cdac_cap_mim
Xcdac_cap_mim_0[6|13] vdac bot5 vss cdac_cap_mim
Xcdac_cap_mim_0[7|13] vdac bot5 vss cdac_cap_mim
Xcdac_cap_mim_0[8|13] vdac bot5 vss cdac_cap_mim
Xcdac_cap_mim_0[9|13] vdac bot5 vss cdac_cap_mim
Xcdac_cap_mim_0[10|13] vdac bot5 vss cdac_cap_mim
Xcdac_cap_mim_0[11|13] vdac bot5 vss cdac_cap_mim
Xcdac_cap_mim_0[12|13] vdac bot5 vss cdac_cap_mim
Xcdac_cap_mim_0[13|13] vdac bot5 vss cdac_cap_mim
Xcdac_cap_mim_0[14|13] vdac bot5 vss cdac_cap_mim
Xcdac_cap_mim_0[15|13] vdac bot5 vss cdac_cap_mim
Xcdac_cap_mim_0[0|14] vdac bot4 vss cdac_cap_mim
Xcdac_cap_mim_0[1|14] vdac bot4 vss cdac_cap_mim
Xcdac_cap_mim_0[2|14] vdac bot4 vss cdac_cap_mim
Xcdac_cap_mim_0[3|14] vdac bot4 vss cdac_cap_mim
Xcdac_cap_mim_0[4|14] vdac bot4 vss cdac_cap_mim
Xcdac_cap_mim_0[5|14] vdac bot4 vss cdac_cap_mim
Xcdac_cap_mim_0[6|14] vdac bot4 vss cdac_cap_mim
Xcdac_cap_mim_0[7|14] vdac bot4 vss cdac_cap_mim
Xcdac_cap_mim_0[8|14] vdac bot4 vss cdac_cap_mim
Xcdac_cap_mim_0[9|14] vdac bot4 vss cdac_cap_mim
Xcdac_cap_mim_0[10|14] vdac bot4 vss cdac_cap_mim
Xcdac_cap_mim_0[11|14] vdac bot4 vss cdac_cap_mim
Xcdac_cap_mim_0[12|14] vdac bot4 vss cdac_cap_mim
Xcdac_cap_mim_0[13|14] vdac bot4 vss cdac_cap_mim
Xcdac_cap_mim_0[14|14] vdac bot4 vss cdac_cap_mim
Xcdac_cap_mim_0[15|14] vdac bot4 vss cdac_cap_mim
Xcdac_cap_mim_0[0|15] vdac bot3 vss cdac_cap_mim
Xcdac_cap_mim_0[1|15] vdac bot3 vss cdac_cap_mim
Xcdac_cap_mim_0[2|15] vdac bot3 vss cdac_cap_mim
Xcdac_cap_mim_0[3|15] vdac bot3 vss cdac_cap_mim
Xcdac_cap_mim_0[4|15] vdac bot3 vss cdac_cap_mim
Xcdac_cap_mim_0[5|15] vdac bot3 vss cdac_cap_mim
Xcdac_cap_mim_0[6|15] vdac bot3 vss cdac_cap_mim
Xcdac_cap_mim_0[7|15] vdac bot3 vss cdac_cap_mim
Xcdac_cap_mim_0[8|15] vdac bot2 vss cdac_cap_mim
Xcdac_cap_mim_0[9|15] vdac bot2 vss cdac_cap_mim
Xcdac_cap_mim_0[10|15] vdac bot2 vss cdac_cap_mim
Xcdac_cap_mim_0[11|15] vdac bot2 vss cdac_cap_mim
Xcdac_cap_mim_0[12|15] vdac bot1 vss cdac_cap_mim
Xcdac_cap_mim_0[13|15] vdac bot1 vss cdac_cap_mim
Xcdac_cap_mim_0[14|15] vdac vss vss cdac_cap_mim
Xcdac_cap_mim_0[15|15] vdac bot0 vss cdac_cap_mim
Xcdac_cdac_switch_1b_6 cdac_cdac_switch_1b_6/bit_b vref bot6 dac_in[6] vss cdac_cdac_switch_1b
Xcdac_cdac_switch_1b_5 cdac_cdac_switch_1b_5/bit_b vref bot4 dac_in[4] vss cdac_cdac_switch_1b
Xcdac_cdac_switch_1b_7 cdac_cdac_switch_1b_7/bit_b vref bot7 dac_in[7] vss cdac_cdac_switch_1b
C0 bot6 vdac 0.12232p
C1 bot1 vdac 1.95125f
C2 vref dac_in[7] 0.11822f
C3 bot1 bot4 -1.15168f
C4 vref dac_in[3] 0.1115f
C5 bot5 bot2 -1.06927f
C6 bot4 vdac 29.54236f
C7 bot3 bot2 0.07657f
C8 vref dac_in[2] 0.11153f
C9 bot5 bot6 2.94808f
C10 bot1 bot5 -0.35642f
C11 bot5 vdac 38.07019f
C12 vdac bot3 7.82655f
C13 bot5 bot4 2.94808f
C14 bot4 bot3 -5.1324f
C15 vref vdac 0.0864f
C16 bot6 bot7 -22.65272f
C17 vdac bot7 0.25123p
C18 vref dac_in[5] 0.1115f
C19 vref dac_in[4] 0.11152f
C20 bot5 bot3 -1.78211f
C21 vdac bot0 0.73999f
C22 bot1 bot2 0.07657f
C23 bot4 bot0 0.06629f
C24 vdac bot2 3.9296f
C25 bot4 bot2 -3.60819f
C26 vref dac_in[6] 0.11822f
C27 vref dac_in[1] 0.1115f
C28 cdac_cdac_switch_1b_7/bit_b vss -1.09134f
C29 dac_in[7] vss 7.08347f
C30 bot4 vss -0.46925f
C31 cdac_cdac_switch_1b_5/bit_b vss -1.07629f
C32 dac_in[4] vss 3.73019f
C33 cdac_cdac_switch_1b_6/bit_b vss -1.07629f
C34 dac_in[6] vss 6.23536f
C35 vdac vss 64.52161f
C36 bot5 vss -2.86555f
C37 bot6 vss -19.94818f
C38 bot7 vss -23.15644f
C39 cdac_cdac_switch_1b_4/bit_b vss -1.07629f
C40 dac_in[5] vss 4.75373f
C41 bot3 vss -2.56394f
C42 vref vss 10.06894f
C43 cdac_cdac_switch_1b_3/bit_b vss -1.07629f
C44 dac_in[3] vss 1.86702f
C45 bot2 vss -1.74071f
C46 cdac_cdac_switch_1b_2/bit_b vss -1.07629f
C47 dac_in[2] vss 1.58821f
C48 bot1 vss -0.94609f
C49 cdac_cdac_switch_1b_1/bit_b vss -1.07476f
C50 dac_in[1] vss 0.84303f
C51 bot0 vss -0.66106f
C52 cdac_cdac_switch_1b_0/bit_b vss -1.07631f
C53 dac_in[0] vss 0.65086f
.ends

.subckt sh_nfet a_30_260# a_n84_0# a_94_0#
X0 a_94_0# a_30_260# a_n84_0# a_94_0# nfet_03v3 ad=1.32p pd=4.64u as=0.61p ps=3.22u w=1u l=0.28u
C0 a_n84_0# a_94_0# 0.06747f
C1 a_30_260# a_94_0# 0.2242f
.ends

.subckt sh_pfet a_28_n136# a_n92_0# w_n230_n138# VSUBS
X0 w_n230_n138# a_28_n136# a_n92_0# w_n230_n138# pfet_03v3 ad=2.76p pd=6.76u as=1.3p ps=5.3u w=2u l=0.28u
C0 a_28_n136# w_n230_n138# 0.15518f
C1 w_n230_n138# a_n92_0# 0.11176f
C2 a_28_n136# a_n92_0# 0.0115f
C3 a_n92_0# VSUBS 0.06093f
C4 a_28_n136# VSUBS 0.07992f
C5 w_n230_n138# VSUBS 1.54147f
.ends

.subckt sh_inv_sh vdd vi vo vss
Xsh_nfet_0 vi vo vss sh_nfet
Xsh_pfet_0 vi vo vdd vss sh_pfet
C0 vo vi 0.25028f
C1 vdd vo 0.07197f
C2 vo vss 0.25534f
C3 vi vss 0.03198f
C4 vdd vss 0.07135f
.ends

.subckt sh_cap_mim m4_n120_n120# m4_0_0# VSUBS
X0 m4_0_0# m4_n120_n120# cap_mim_2f0_m4m5_noshield c_width=15u c_length=10u
C0 m4_0_0# m4_n120_n120# 0.73993f
C1 m4_0_0# VSUBS 2.59242f
C2 m4_n120_n120# VSUBS 1.78179f
.ends

.subckt sh_nfet$2 a_30_n132# a_n84_0# a_94_0#
X0 a_94_0# a_30_n132# a_n84_0# a_94_0# nfet_03v3 ad=5.28p pd=10.64u as=2.44p ps=9.22u w=4u l=0.28u
C0 a_n84_0# a_30_n132# 0.02741f
C1 a_n84_0# a_94_0# 0.3974f
C2 a_30_n132# a_94_0# 0.24343f
.ends

.subckt sh_pfet$2 a_28_n136# a_n92_0# w_n230_n138# VSUBS
X0 w_n230_n138# a_28_n136# a_n92_0# w_n230_n138# pfet_03v3 ad=11.04p pd=18.76u as=5.2p ps=17.3u w=8u l=0.28u
C0 a_n92_0# a_28_n136# 0.05772f
C1 a_28_n136# w_n230_n138# 0.20096f
C2 a_n92_0# w_n230_n138# 0.57114f
C3 a_n92_0# VSUBS 0.24066f
C4 a_28_n136# VSUBS 0.07668f
C5 w_n230_n138# VSUBS 4.25118f
.ends

.subckt sample_hold vdd sample_en clkb vin
Xsh_inv_sh_0 vdd sample_en clkb vin sh_inv_sh
Xsh_cap_mim_0 vdd vin vin sh_cap_mim
Xsh_nfet$2_0 sample_en vdd vin sh_nfet$2
Xsh_pfet$2_0 clkb vin vdd vin sh_pfet$2
C0 vdd clkb 0.27538f
C1 vdd sample_en 0.08742f
C2 clkb sample_en 0.1653f
C3 clkb vin -0.20354f
C4 sample_en vin 0.26362f
C5 vdd vin 2.91072f
.ends

.subckt sar_adc_top dvss done dout[0] dout[1] dout[2] dout[3] dout[4] dout[5] dout[6]
+ dout[7] vin_p vref
Xasync_sar_0 dvss dvss dvss async_sar_0/sample_en dvss done dout[0] cdac_8bit_0/dac_in[0]
+ dout[1] dvss dout[2] dvss dout[3] dvss dout[4] cdac_8bit_0/dac_in[4] dout[5] cdac_8bit_0/dac_in[5]
+ dout[6] cdac_8bit_0/dac_in[6] dout[7] dvss async_sar_0/a_30228_54264# async_sar_0/a_20908_46000#
+ async_sar_0/a_37028_54264# async_sar_0/a_47028_19064# async_sar_0/a_33308_24800#
+ async_sar_0/a_23428_54264# async_sar_0/a_50628_54264# async_sar_0/sample_en async_sar_0/a_16628_54264#
+ async_sar_0/a_43828_54264# async_sar_0/a_9828_54264# async_sar_0/a_35308_29600#
+ dvss async_sar
Xstrongarm_comp_0 dvss dvss strongarm_comp_0/out_n vref dvss dvss strongarm_comp_0/comp_comp_xor_fast_0/comp_comp_nand_3v3_2/b
+ strongarm_comp_0/comp_comp_inv_3v3_1/vi strongarm_comp_0/comp_comp_xor_fast_0/comp_comp_nand_3v3_3/a
+ strongarm_comp_0/comp_comp_xor_fast_0/comp_comp_nand_3v3_3/b strongarm_comp_0/comp_comp_inv_3v3_0/vi
+ vref dvss strongarm_comp
Xcdac_8bit_0 cdac_8bit_0/bot6 cdac_8bit_0/bot5 cdac_8bit_0/bot4 cdac_8bit_0/bot3 cdac_8bit_0/bot2
+ cdac_8bit_0/bot1 cdac_8bit_0/bot0 vref dvss cdac_8bit_0/dac_in[0] dvss cdac_8bit_0/dac_in[6]
+ cdac_8bit_0/dac_in[5] cdac_8bit_0/dac_in[4] dvss dvss cdac_8bit_0/cdac_cdac_switch_1b_1/bit_b
+ cdac_8bit_0/bot7 cdac_8bit_0/cdac_cdac_switch_1b_2/bit_b cdac_8bit_0/cdac_cdac_switch_1b_3/bit_b
+ vref dvss dvss cdac_8bit
Xsample_hold_0 vref async_sar_0/sample_en sample_hold_0/clkb dvss sample_hold
C0 cdac_8bit_0/dac_in[5] async_sar_0/a_16628_54264# 0.06316f
C1 async_sar_0/a_30228_54264# cdac_8bit_0/dac_in[4] 0.06316f
C2 async_sar_0/a_37028_54264# cdac_8bit_0/dac_in[4] 0.06316f
C3 async_sar_0/a_50628_54264# cdac_8bit_0/dac_in[0] 0.07208f
C4 async_sar_0/a_50628_54264# cdac_8bit_0/dac_in[6] 0.07054f
C5 async_sar_0/a_35308_29600# async_sar_0/sample_en 0.06114f
C6 dout[7] async_sar_0/sample_en 0.07696f
C7 vref vin_p 0.04447f
C8 async_sar_0/a_9828_54264# async_sar_0/sample_en 0.06551f
C9 async_sar_0/a_43828_54264# async_sar_0/sample_en 0.07025f
C10 cdac_8bit_0/dac_in[4] async_sar_0/sample_en 0.13631f
C11 async_sar_0/a_9828_54264# cdac_8bit_0/dac_in[4] 0.06316f
C12 dout[0] dout[1] 0.12306f
C13 vref async_sar_0/sample_en 0.55635f
C14 async_sar_0/a_23428_54264# cdac_8bit_0/dac_in[0] 0.0647f
C15 async_sar_0/a_43828_54264# cdac_8bit_0/dac_in[4] 0.06316f
C16 async_sar_0/a_23428_54264# cdac_8bit_0/dac_in[6] 0.06316f
C17 dout[5] dout[4] 0.12306f
C18 async_sar_0/sample_en async_sar_0/a_16628_54264# 0.06551f
C19 async_sar_0/a_50628_54264# cdac_8bit_0/dac_in[5] 0.07054f
C20 cdac_8bit_0/dac_in[0] cdac_8bit_0/dac_in[6] 0.0647f
C21 async_sar_0/a_47028_19064# async_sar_0/sample_en 0.06751f
C22 done async_sar_0/sample_en 0.0252f
C23 vref cdac_8bit_0/dac_in[4] 0.20653f
C24 cdac_8bit_0/dac_in[4] async_sar_0/a_16628_54264# 0.06316f
C25 async_sar_0/a_33308_24800# async_sar_0/sample_en 0.13435f
C26 dout[0] async_sar_0/sample_en 0.07686f
C27 dout[5] async_sar_0/sample_en 0.07696f
C28 async_sar_0/a_23428_54264# cdac_8bit_0/dac_in[5] 0.06316f
C29 async_sar_0/a_50628_54264# async_sar_0/sample_en 0.0899f
C30 cdac_8bit_0/dac_in[5] cdac_8bit_0/dac_in[0] 0.0647f
C31 cdac_8bit_0/dac_in[5] cdac_8bit_0/dac_in[6] 9.84171f
C32 vref strongarm_comp_0/comp_comp_xor_fast_0/comp_comp_nand_3v3_3/b 0.03793f
C33 async_sar_0/a_50628_54264# cdac_8bit_0/dac_in[4] 0.07054f
C34 async_sar_0/a_30228_54264# cdac_8bit_0/dac_in[0] 0.0647f
C35 async_sar_0/a_30228_54264# cdac_8bit_0/dac_in[6] 0.06316f
C36 async_sar_0/a_37028_54264# cdac_8bit_0/dac_in[0] 0.0647f
C37 dout[6] dout[7] 0.12306f
C38 async_sar_0/a_37028_54264# cdac_8bit_0/dac_in[6] 0.06316f
C39 dout[6] async_sar_0/sample_en 0.07696f
C40 dout[2] dout[3] 0.12306f
C41 async_sar_0/a_23428_54264# async_sar_0/sample_en 0.06551f
C42 vref strongarm_comp_0/comp_comp_inv_3v3_1/vi 0.05124f
C43 dout[4] dout[3] 0.12306f
C44 cdac_8bit_0/dac_in[0] dout[7] 0.06026f
C45 cdac_8bit_0/dac_in[0] async_sar_0/sample_en 0.1351f
C46 async_sar_0/sample_en cdac_8bit_0/dac_in[6] 4.31552f
C47 cdac_8bit_0/dac_in[0] async_sar_0/a_9828_54264# 0.0647f
C48 async_sar_0/a_9828_54264# cdac_8bit_0/dac_in[6] 0.06322f
C49 async_sar_0/a_23428_54264# cdac_8bit_0/dac_in[4] 0.06316f
C50 dout[2] dout[1] 0.12306f
C51 async_sar_0/a_43828_54264# cdac_8bit_0/dac_in[0] 0.0647f
C52 async_sar_0/a_43828_54264# cdac_8bit_0/dac_in[6] 0.06316f
C53 async_sar_0/a_30228_54264# cdac_8bit_0/dac_in[5] 0.06316f
C54 cdac_8bit_0/dac_in[0] cdac_8bit_0/dac_in[4] 0.06485f
C55 async_sar_0/a_37028_54264# cdac_8bit_0/dac_in[5] 0.06316f
C56 cdac_8bit_0/dac_in[4] cdac_8bit_0/dac_in[6] 0.13725f
C57 vin_p sample_hold_0/clkb 0.01619f
C58 vref cdac_8bit_0/dac_in[6] 0.15082f
C59 async_sar_0/sample_en dout[3] 0.07696f
C60 cdac_8bit_0/dac_in[0] async_sar_0/a_16628_54264# 0.0647f
C61 vref strongarm_comp_0/comp_comp_xor_fast_0/comp_comp_nand_3v3_2/b 0.02826f
C62 async_sar_0/a_16628_54264# cdac_8bit_0/dac_in[6] 0.06319f
C63 vref strongarm_comp_0/comp_comp_xor_fast_0/comp_comp_nand_3v3_3/a 0.04417f
C64 async_sar_0/sample_en dout[2] 0.07696f
C65 cdac_8bit_0/dac_in[5] async_sar_0/sample_en 0.13679f
C66 dout[5] dout[6] 0.12306f
C67 cdac_8bit_0/dac_in[5] async_sar_0/a_9828_54264# 0.06319f
C68 vref strongarm_comp_0/comp_comp_inv_3v3_0/vi 0.05531f
C69 async_sar_0/sample_en dout[1] 0.07696f
C70 async_sar_0/a_43828_54264# cdac_8bit_0/dac_in[5] 0.06316f
C71 dout[4] async_sar_0/sample_en 0.07696f
C72 async_sar_0/a_30228_54264# async_sar_0/sample_en 0.06551f
C73 vin_p async_sar_0/sample_en 0.05565f
C74 cdac_8bit_0/dac_in[5] cdac_8bit_0/dac_in[4] 9.35947f
C75 async_sar_0/a_37028_54264# async_sar_0/sample_en 0.06789f
C76 vref cdac_8bit_0/dac_in[5] 0.9435f
C77 async_sar_0/a_20908_46000# async_sar_0/sample_en 0.06751f
C78 vin_p dvss 0.96824f
C79 sample_hold_0/clkb dvss -0.51475f
C80 async_sar_0/sample_en dvss 30.34163f
C81 cdac_8bit_0/cdac_cdac_switch_1b_7/bit_b dvss -1.09134f
C82 cdac_8bit_0/bot4 dvss -2.61962f
C83 cdac_8bit_0/cdac_cdac_switch_1b_5/bit_b dvss -1.09134f
C84 cdac_8bit_0/dac_in[4] dvss 33.28629f
C85 cdac_8bit_0/cdac_cdac_switch_1b_6/bit_b dvss -1.09134f
C86 cdac_8bit_0/dac_in[6] dvss 33.86838f
C87 cdac_8bit_0/bot5 dvss -3.98978f
C88 cdac_8bit_0/bot6 dvss -21.89317f
C89 cdac_8bit_0/bot7 dvss -29.93657f
C90 cdac_8bit_0/cdac_cdac_switch_1b_4/bit_b dvss -1.09134f
C91 cdac_8bit_0/dac_in[5] dvss 22.4875f
C92 cdac_8bit_0/bot3 dvss -4.45977f
C93 vref dvss -5.992f
C94 cdac_8bit_0/cdac_cdac_switch_1b_3/bit_b dvss -0.98981f
C95 cdac_8bit_0/bot2 dvss -2.77252f
C96 cdac_8bit_0/cdac_cdac_switch_1b_2/bit_b dvss -0.99253f
C97 cdac_8bit_0/bot1 dvss -1.69004f
C98 cdac_8bit_0/cdac_cdac_switch_1b_1/bit_b dvss -0.99149f
C99 cdac_8bit_0/bot0 dvss -1.11758f
C100 cdac_8bit_0/cdac_cdac_switch_1b_0/bit_b dvss -1.09134f
C101 cdac_8bit_0/dac_in[0] dvss 25.3749f
C102 strongarm_comp_0/comp_comp_xor_fast_0/comp_comp_nand_3v3_3/a dvss -0.64911f
C103 strongarm_comp_0/comp_comp_xor_fast_0/comp_comp_nand_3v3_3/b dvss -0.57915f
C104 strongarm_comp_0/comp_comp_xor_fast_0/comp_comp_nand_3v3_2/b dvss -0.95029f
C105 strongarm_comp_0/out_n dvss -1.30343f
C106 strongarm_comp_0/comp_comp_inv_3v3_1/vi dvss -1.0176f
C107 strongarm_comp_0/comp_comp_inv_3v3_0/vi dvss -0.89606f
C108 done dvss 0.06054f
C109 dout[7] dvss 0.21867f
C110 dout[6] dvss 0.21702f
C111 dout[5] dvss 0.21686f
C112 dout[4] dvss 0.21683f
C113 dout[3] dvss 0.21683f
C114 dout[2] dvss 0.21683f
C115 dout[1] dvss 0.21683f
C116 dout[0] dvss 0.58225f
C117 async_sar_0/a_47028_19064# dvss 0.11454f
C118 async_sar_0/a_33308_24800# dvss 0.1076f
C119 async_sar_0/a_20908_46000# dvss 0.11317f
C120 async_sar_0/a_35308_29600# dvss 0.10179f
C121 async_sar_0/a_50628_54264# dvss 0.5039f
C122 async_sar_0/a_43828_54264# dvss 0.44605f
C123 async_sar_0/a_37028_54264# dvss 0.44597f
C124 async_sar_0/a_30228_54264# dvss 0.44572f
C125 async_sar_0/a_23428_54264# dvss 0.44556f
C126 async_sar_0/a_16628_54264# dvss 0.44515f
C127 async_sar_0/a_9828_54264# dvss 0.46773f
.ends
