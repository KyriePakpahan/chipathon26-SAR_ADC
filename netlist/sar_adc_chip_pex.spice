* NGSPICE file created from sar_adc_chip.ext - technology: gf180mcuD

.subckt async_sar start comp_out_p comp_done sample_en rst_latch done dout[0] dac_in[0]
+ dout[1] dac_in[1] dout[2] dac_in[2] dout[3] dac_in[3] dout[4] dac_in[4] dout[5]
+ dac_in[5] dout[6] dac_in[6] dout[7] dac_in[7] a_4108_41600# a_36908_54400# a_37028_9464#
+ a_30228_54264# a_34108_29600# a_5708_10960# a_35308_41600# a_38108_54400# a_7708_46000#
+ a_20908_46000# a_37028_54264# a_36908_12400# a_47028_19064# a_33308_24800# a_8108_15760#
+ a_34108_41600# a_2908_33600# a_36908_1200# a_38108_12400# a_5708_6160# a_23428_54264#
+ a_5708_15760# a_38108_6800# a_2228_20424# a_50628_54264# a_2908_37600# a_33308_19200#
+ a_16628_54264# a_34108_33600# a_7708_41600# a_38908_41600# a_8108_6160# a_2228_10824#
+ a_38228_3864# a_43828_54264# a_8108_20560# a_5708_20560# a_36908_6800# a_34108_37600#
+ a_2908_29600# a_36908_50400# a_38108_1200# a_9828_54264# a_37028_3864# a_38228_9464#
+ a_2228_15624# a_38108_50400# a_35308_29600# a_3428_1424# a_2908_41600# a_3028_54264#
+ a_8108_10960# a_2228_6024#
X0 start a_2908_50400# a_3028_54264# start pfet_03v3 ad=1.38p pd=4.76u as=0.65p ps=3.3u w=1u l=0.28u
X1 start a_50908_41600# dout[7] start pfet_03v3 ad=1.104p pd=4.36u as=0.52p ps=2.9u w=0.8u l=0.28u
X2 start a_42908_12400# a_44108_12400# start pfet_03v3 ad=1.38p pd=4.76u as=0.65p ps=3.3u w=1u l=0.28u
X3 start comp_done a_33308_19200# start pfet_03v3 ad=1.38p pd=4.76u as=0.65p ps=3.3u w=1u l=0.28u
X4 start a_9308_10960# a_11708_10960# start nfet_03v3 ad=0.66p pd=3.64u as=0.305p ps=2.22u w=0.5u l=0.28u
X5 start a_6508_46000# a_7708_46000# start nfet_03v3 ad=0.66p pd=3.64u as=0.305p ps=2.22u w=0.5u l=0.28u
X6 start a_16228_10824# a_16108_10960# start nfet_03v3 ad=0.66p pd=3.64u as=0.305p ps=2.22u w=0.5u l=0.28u
X7 a_12694_28400# a_10108_29600# a_12508_29600# start nfet_03v3 ad=0.305p pd=2.22u as=0.305p ps=2.22u w=0.5u l=0.28u
X8 start a_44108_1200# a_45308_1200# start nfet_03v3 ad=0.66p pd=3.64u as=0.305p ps=2.22u w=0.5u l=0.28u
X9 start dout[5] a_42508_33600# start nfet_03v3 ad=0.577p pd=3.52u as=0.2646p ps=2.1u w=0.42u l=0.28u
X10 start a_48908_1200# a_50108_1200# start pfet_03v3 ad=1.38p pd=4.76u as=0.65p ps=3.3u w=1u l=0.28u
X11 start a_37028_9464# a_35828_9464# start nfet_03v3 ad=0.66p pd=3.64u as=0.305p ps=2.22u w=0.5u l=0.28u
X12 start a_20908_46000# a_39708_24800# start pfet_03v3 ad=1.104p pd=4.36u as=0.52p ps=2.9u w=0.8u l=0.28u
X13 start a_9308_20560# a_11708_20560# start pfet_03v3 ad=1.38p pd=4.76u as=0.65p ps=3.3u w=1u l=0.28u
X14 start a_53708_6800# a_54908_6800# start pfet_03v3 ad=1.38p pd=4.76u as=0.65p ps=3.3u w=1u l=0.28u
X15 start a_46508_12400# a_47708_12400# start nfet_03v3 ad=0.66p pd=3.64u as=0.305p ps=2.22u w=0.5u l=0.28u
X16 start comp_out_p a_24508_50400# start pfet_03v3 ad=1.104p pd=4.36u as=0.52p ps=2.9u w=0.8u l=0.28u
X17 start a_48508_37600# a_50908_37600# start pfet_03v3 ad=1.38p pd=4.76u as=0.65p ps=3.3u w=1u l=0.28u
X18 start a_25828_1224# a_24508_1360# start pfet_03v3 ad=1.38p pd=4.76u as=0.65p ps=3.3u w=1u l=0.28u
X19 start a_10908_50400# a_9828_54264# start pfet_03v3 ad=1.38p pd=4.76u as=0.65p ps=3.3u w=1u l=0.28u
X20 start a_10628_15624# a_9494_14400# start nfet_03v3 ad=0.66p pd=3.64u as=0.305p ps=2.22u w=0.5u l=0.28u
X21 a_5708_10960# a_2228_10824# a_8108_10960# start pfet_03v3 ad=0.65p pd=3.3u as=0.65p ps=3.3u w=1u l=0.28u
X22 start a_44908_54400# a_46294_53200# start nfet_03v3 ad=0.66p pd=3.64u as=0.305p ps=2.22u w=0.5u l=0.28u
X23 start a_20908_1360# a_19708_1360# start nfet_03v3 ad=0.577p pd=3.52u as=0.2646p ps=2.1u w=0.42u l=2.4u
X24 start a_52628_15064# a_51428_15064# start nfet_03v3 ad=0.66p pd=3.64u as=0.305p ps=2.22u w=0.5u l=0.28u
X25 start a_34508_1200# a_35708_1200# start nfet_03v3 ad=0.66p pd=3.64u as=0.305p ps=2.22u w=0.5u l=0.28u
X26 start a_10108_41600# a_12508_41600# start pfet_03v3 ad=1.38p pd=4.76u as=0.65p ps=3.3u w=1u l=0.28u
X27 start sample_en a_46628_3864# start nfet_03v3 ad=0.66p pd=3.64u as=0.305p ps=2.22u w=0.5u l=0.28u
X28 start a_46628_3864# a_45428_3864# start pfet_03v3 ad=1.38p pd=4.76u as=0.65p ps=3.3u w=1u l=0.28u
X29 a_9494_14400# a_8108_15760# a_9308_15760# start nfet_03v3 ad=0.305p pd=2.22u as=0.305p ps=2.22u w=0.5u l=0.28u
X30 start a_9828_54264# a_9708_54400# start nfet_03v3 ad=0.577p pd=3.52u as=0.2646p ps=2.1u w=0.42u l=0.28u
X31 start a_50108_6800# a_51308_6800# start nfet_03v3 ad=0.66p pd=3.64u as=0.305p ps=2.22u w=0.5u l=0.28u
X32 start a_18508_37600# a_19894_36400# start nfet_03v3 ad=0.66p pd=3.64u as=0.305p ps=2.22u w=0.5u l=0.28u
X33 start a_2228_6024# a_2108_6160# start nfet_03v3 ad=0.66p pd=3.64u as=0.305p ps=2.22u w=0.5u l=0.28u
X34 a_51094_40400# a_48508_41600# a_50908_41600# start nfet_03v3 ad=0.305p pd=2.22u as=0.305p ps=2.22u w=0.5u l=0.28u
X35 start a_22108_6160# a_24508_6160# start pfet_03v3 ad=1.38p pd=4.76u as=0.65p ps=3.3u w=1u l=0.28u
X36 start a_39308_6800# a_40508_6800# start pfet_03v3 ad=1.38p pd=4.76u as=0.65p ps=3.3u w=1u l=0.28u
X37 start a_16228_10824# a_16108_10960# start pfet_03v3 ad=1.38p pd=4.76u as=0.65p ps=3.3u w=1u l=0.28u
X38 start comp_out_p a_44908_50400# start nfet_03v3 ad=0.577p pd=3.52u as=0.2646p ps=2.1u w=0.42u l=0.28u
X39 start a_9308_15760# a_11708_15760# start pfet_03v3 ad=1.38p pd=4.76u as=0.65p ps=3.3u w=1u l=0.28u
X40 start a_41308_37600# a_43708_37600# start pfet_03v3 ad=1.38p pd=4.76u as=0.65p ps=3.3u w=1u l=0.28u
X41 start a_2908_37600# a_10108_37600# start pfet_03v3 ad=1.104p pd=4.36u as=0.52p ps=2.9u w=0.8u l=0.28u
X42 a_16108_15760# a_15028_15624# a_17308_15760# start nfet_03v3 ad=0.305p pd=2.22u as=0.305p ps=2.22u w=0.5u l=0.28u
X43 start a_53708_1200# a_54908_1200# start pfet_03v3 ad=1.38p pd=4.76u as=0.65p ps=3.3u w=1u l=0.28u
X44 start start a_17708_54400# start nfet_03v3 ad=0.577p pd=3.52u as=0.2646p ps=2.1u w=0.42u l=0.28u
X45 start a_17308_29600# a_19708_29600# start pfet_03v3 ad=1.38p pd=4.76u as=0.65p ps=3.3u w=1u l=0.28u
X46 start a_47828_9464# a_46628_9464# start nfet_03v3 ad=0.66p pd=3.64u as=0.305p ps=2.22u w=0.5u l=0.28u
X47 start a_2908_46000# a_4108_46000# start pfet_03v3 ad=1.38p pd=4.76u as=0.65p ps=3.3u w=1u l=0.28u
X48 start a_19708_46000# a_20908_46000# start nfet_03v3 ad=0.66p pd=3.64u as=0.305p ps=2.22u w=0.5u l=0.28u
X49 start dout[5] a_49708_33600# start pfet_03v3 ad=1.104p pd=4.36u as=0.52p ps=2.9u w=0.8u l=0.28u
X50 start a_50508_54400# dac_in[7] start pfet_03v3 ad=1.38p pd=4.76u as=0.65p ps=3.3u w=1u l=0.28u
X51 start a_11308_37600# a_12694_36400# start nfet_03v3 ad=0.66p pd=3.64u as=0.305p ps=2.22u w=0.5u l=0.28u
X52 start comp_out_p comp_out_p start nfet_03v3 ad=0.66p pd=3.64u as=0.305p ps=2.22u w=0.5u l=0.28u
X53 a_43894_40400# a_41308_41600# a_43708_41600# start nfet_03v3 ad=0.305p pd=2.22u as=0.305p ps=2.22u w=0.5u l=0.28u
X54 start a_59828_15064# a_58628_15064# start pfet_03v3 ad=1.38p pd=4.76u as=0.65p ps=3.3u w=1u l=0.28u
X55 start a_33308_12400# a_34508_12400# start nfet_03v3 ad=0.66p pd=3.64u as=0.305p ps=2.22u w=0.5u l=0.28u
X56 start start a_30228_54264# start pfet_03v3 ad=1.38p pd=4.76u as=0.65p ps=3.3u w=1u l=0.28u
X57 start a_2908_41600# a_10108_41600# start nfet_03v3 ad=0.577p pd=3.52u as=0.2646p ps=2.1u w=0.42u l=0.28u
X58 start a_54908_6800# a_56108_6800# start nfet_03v3 ad=0.66p pd=3.64u as=0.305p ps=2.22u w=0.5u l=0.28u
X59 start start a_4108_54400# start pfet_03v3 ad=1.104p pd=4.36u as=0.52p ps=2.9u w=0.8u l=0.28u
X60 a_19894_32400# a_17308_33600# a_19708_33600# start nfet_03v3 ad=0.305p pd=2.22u as=0.305p ps=2.22u w=0.5u l=0.28u
X61 start a_39308_1200# a_40508_1200# start pfet_03v3 ad=1.38p pd=4.76u as=0.65p ps=3.3u w=1u l=0.28u
X62 start a_5708_6160# a_4508_6160# start nfet_03v3 ad=0.577p pd=3.52u as=0.2646p ps=2.1u w=0.42u l=2.4u
X63 start a_17308_15760# a_18508_15760# start pfet_03v3 ad=1.38p pd=4.76u as=0.65p ps=3.3u w=1u l=0.28u
X64 start a_44108_6800# a_45308_6800# start pfet_03v3 ad=1.38p pd=4.76u as=0.65p ps=3.3u w=1u l=0.28u
X65 start a_12508_46000# a_13708_46000# start nfet_03v3 ad=0.66p pd=3.64u as=0.305p ps=2.22u w=0.5u l=0.28u
X66 start a_47708_12400# a_48908_12400# start pfet_03v3 ad=1.38p pd=4.76u as=0.65p ps=3.3u w=1u l=0.28u
X67 start dac_in[0] dac_in[0] start nfet_03v3 ad=0.577p pd=3.52u as=0.2646p ps=2.1u w=0.42u l=0.28u
X68 start a_34108_37600# a_41308_37600# start nfet_03v3 ad=0.577p pd=3.52u as=0.2646p ps=2.1u w=0.42u l=0.28u
X69 start a_33308_24800# sample_en start pfet_03v3 ad=1.38p pd=4.76u as=0.65p ps=3.3u w=1u l=0.28u
X70 start a_9708_54400# dac_in[1] start pfet_03v3 ad=1.38p pd=4.76u as=0.65p ps=3.3u w=1u l=0.28u
X71 start a_23428_54264# a_23308_54400# start pfet_03v3 ad=1.104p pd=4.36u as=0.52p ps=2.9u w=0.8u l=0.28u
X72 start a_51708_50400# a_53094_49200# start nfet_03v3 ad=0.66p pd=3.64u as=0.305p ps=2.22u w=0.5u l=0.28u
X73 start comp_out_p a_17308_29600# start nfet_03v3 ad=0.577p pd=3.52u as=0.2646p ps=2.1u w=0.42u l=0.28u
X74 start a_3428_1424# start start nfet_03v3 ad=0.305p pd=2.22u as=0.40951n ps=2.30248m w=0.5u l=0.28u
X75 start a_40508_6800# a_41708_6800# start nfet_03v3 ad=0.66p pd=3.64u as=0.305p ps=2.22u w=0.5u l=0.28u
X76 start a_35708_1200# a_36908_1200# start nfet_03v3 ad=0.66p pd=3.64u as=0.305p ps=2.22u w=0.5u l=0.28u
X77 a_5494_49200# a_2908_50400# a_3028_54264# start nfet_03v3 ad=0.305p pd=2.22u as=0.305p ps=2.22u w=0.5u l=0.28u
X78 start a_50108_12400# a_51308_12400# start pfet_03v3 ad=1.38p pd=4.76u as=0.65p ps=3.3u w=1u l=0.28u
X79 start a_57428_15064# a_56228_15064# start nfet_03v3 ad=0.66p pd=3.64u as=0.305p ps=2.22u w=0.5u l=0.28u
X80 start a_35308_29600# comp_out_p start pfet_03v3 ad=1.38p pd=4.76u as=0.65p ps=3.3u w=1u l=0.28u
X81 start a_44108_1200# a_45308_1200# start pfet_03v3 ad=1.38p pd=4.76u as=0.65p ps=3.3u w=1u l=0.28u
X82 start a_7708_41600# a_17308_41600# start pfet_03v3 ad=1.104p pd=4.36u as=0.52p ps=2.9u w=0.8u l=0.28u
X83 start start start start pfet_03v3 ad=0.65p pd=3.3u as=0.40171n ps=2.32842m w=1u l=0.28u
X84 start a_42508_29600# a_43894_28400# start nfet_03v3 ad=0.66p pd=3.64u as=0.305p ps=2.22u w=0.5u l=0.28u
X85 start start start start pfet_03v3 ad=0.65p pd=3.3u as=0 ps=0 w=1u l=0.28u
X86 start a_54908_1200# a_56108_1200# start nfet_03v3 ad=0.66p pd=3.64u as=0.305p ps=2.22u w=0.5u l=0.28u
X87 start a_50228_3864# a_49028_3864# start nfet_03v3 ad=0.66p pd=3.64u as=0.305p ps=2.22u w=0.5u l=0.28u
X88 start a_16508_54400# dac_in[2] start pfet_03v3 ad=1.38p pd=4.76u as=0.65p ps=3.3u w=1u l=0.28u
X89 start sample_en a_35708_24800# start pfet_03v3 ad=1.38p pd=4.76u as=0.65p ps=3.3u w=1u l=0.28u
X90 start a_46628_15064# a_45428_15064# start pfet_03v3 ad=1.38p pd=4.76u as=0.65p ps=3.3u w=1u l=0.28u
X91 start comp_out_p a_24508_50400# start nfet_03v3 ad=0.577p pd=3.52u as=0.2646p ps=2.1u w=0.42u l=0.28u
X92 start a_10908_50400# a_12294_49200# start nfet_03v3 ad=0.66p pd=3.64u as=0.305p ps=2.22u w=0.5u l=0.28u
X93 start a_8908_46000# a_10108_46000# start pfet_03v3 ad=1.38p pd=4.76u as=0.65p ps=3.3u w=1u l=0.28u
X94 start comp_out_p a_48508_37600# start pfet_03v3 ad=1.104p pd=4.36u as=0.52p ps=2.9u w=0.8u l=0.28u
X95 start a_47028_19064# done start nfet_03v3 ad=0.66p pd=3.64u as=0.305p ps=2.22u w=0.5u l=0.28u
X96 start start a_34108_29600# start pfet_03v3 ad=1.38p pd=4.76u as=0.65p ps=3.3u w=1u l=0.28u
X97 start a_45308_1200# a_46508_1200# start nfet_03v3 ad=0.66p pd=3.64u as=0.305p ps=2.22u w=0.5u l=0.28u
X98 start a_45308_6800# a_46508_6800# start nfet_03v3 ad=0.66p pd=3.64u as=0.305p ps=2.22u w=0.5u l=0.28u
X99 start a_12508_37600# dout[2] start pfet_03v3 ad=1.104p pd=4.36u as=0.52p ps=2.9u w=0.8u l=0.28u
X100 start a_18508_6160# a_17308_6160# start pfet_03v3 ad=0.6034p pd=3.64u as=0.2822p ps=2.18u w=0.42u l=2u
X101 start a_34508_6800# a_35708_6800# start pfet_03v3 ad=1.38p pd=4.76u as=0.65p ps=3.3u w=1u l=0.28u
X102 start a_42508_41600# a_43708_41600# start pfet_03v3 ad=1.38p pd=4.76u as=0.65p ps=3.3u w=1u l=0.28u
X103 start a_7708_46000# a_8908_46000# start pfet_03v3 ad=1.38p pd=4.76u as=0.65p ps=3.3u w=1u l=0.28u
X104 start a_50228_9464# a_49028_9464# start nfet_03v3 ad=0.66p pd=3.64u as=0.305p ps=2.22u w=0.5u l=0.28u
X105 start comp_out_p comp_out_p start pfet_03v3 ad=1.38p pd=4.76u as=0.65p ps=3.3u w=1u l=0.28u
X106 start start dac_in[4] start pfet_03v3 ad=1.38p pd=4.76u as=0.65p ps=3.3u w=1u l=0.28u
X107 start a_43828_54264# a_43708_54400# start pfet_03v3 ad=1.104p pd=4.36u as=0.52p ps=2.9u w=0.8u l=0.28u
X108 a_20908_1360# a_17308_1360# a_23308_1360# start nfet_03v3 ad=0.305p pd=2.22u as=0.305p ps=2.22u w=0.5u l=0.28u
X109 start dac_in[2] dac_in[2] start pfet_03v3 ad=1.104p pd=4.36u as=0.52p ps=2.9u w=0.8u l=0.28u
X110 start comp_out_p comp_out_p start pfet_03v3 ad=1.38p pd=4.76u as=0.65p ps=3.3u w=1u l=0.28u
X111 start a_23428_10824# a_22108_10960# start pfet_03v3 ad=1.38p pd=4.76u as=0.65p ps=3.3u w=1u l=0.28u
X112 start dout[2] a_18508_37600# start nfet_03v3 ad=0.577p pd=3.52u as=0.2646p ps=2.1u w=0.42u l=0.28u
X113 start start a_40908_24800# start pfet_03v3 ad=1.104p pd=4.36u as=0.52p ps=2.9u w=0.8u l=0.28u
X114 start a_38908_41600# a_48508_41600# start nfet_03v3 ad=0.577p pd=3.52u as=0.2646p ps=2.1u w=0.42u l=0.28u
X115 start start a_34108_33600# start nfet_03v3 ad=0.66p pd=3.64u as=0.305p ps=2.22u w=0.5u l=0.28u
X116 start a_55028_3864# a_53828_3864# start nfet_03v3 ad=0.66p pd=3.64u as=0.305p ps=2.22u w=0.5u l=0.28u
X117 start a_12508_41600# dout[3] start nfet_03v3 ad=0.577p pd=3.52u as=0.2646p ps=2.1u w=0.42u l=0.28u
X118 start a_3428_1424# start start pfet_03v3 ad=0.65p pd=3.3u as=0 ps=0 w=1u l=0.28u
X119 start a_38108_12400# a_39308_12400# start nfet_03v3 ad=0.66p pd=3.64u as=0.305p ps=2.22u w=0.5u l=0.28u
X120 start a_22108_15760# a_24508_15760# start nfet_03v3 ad=0.66p pd=3.64u as=0.305p ps=2.22u w=0.5u l=0.28u
X121 start comp_out_p comp_out_p start nfet_03v3 ad=0.66p pd=3.64u as=0.305p ps=2.22u w=0.5u l=0.28u
X122 start done a_33308_24800# start nfet_03v3 ad=0.66p pd=3.64u as=0.305p ps=2.22u w=0.5u l=0.28u
X123 start rst_latch rst_latch start nfet_03v3 ad=0.577p pd=3.52u as=0.2646p ps=2.1u w=0.42u l=0.28u
X124 start a_44228_15064# a_44108_15200# start nfet_03v3 ad=0.66p pd=3.64u as=0.305p ps=2.22u w=0.5u l=0.28u
X125 start a_17308_46000# a_18508_46000# start nfet_03v3 ad=0.66p pd=3.64u as=0.305p ps=2.22u w=0.5u l=0.28u
X126 start a_34508_1200# a_35708_1200# start pfet_03v3 ad=1.38p pd=4.76u as=0.65p ps=3.3u w=1u l=0.28u
X127 start a_10628_6024# a_9494_4800# start nfet_03v3 ad=0.66p pd=3.64u as=0.305p ps=2.22u w=0.5u l=0.28u
X128 start a_43708_37600# dout[6] start nfet_03v3 ad=0.577p pd=3.52u as=0.2646p ps=2.1u w=0.42u l=0.28u
X129 start a_36908_54400# dac_in[5] start pfet_03v3 ad=1.38p pd=4.76u as=0.65p ps=3.3u w=1u l=0.28u
X130 start a_40628_3864# a_39428_3864# start nfet_03v3 ad=0.66p pd=3.64u as=0.305p ps=2.22u w=0.5u l=0.28u
X131 start a_15028_6024# a_14908_6160# start nfet_03v3 ad=0.66p pd=3.64u as=0.305p ps=2.22u w=0.5u l=0.28u
X132 start dac_in[3] dac_in[3] start pfet_03v3 ad=1.104p pd=4.36u as=0.52p ps=2.9u w=0.8u l=0.28u
X133 start a_55028_9464# a_53828_9464# start nfet_03v3 ad=0.66p pd=3.64u as=0.305p ps=2.22u w=0.5u l=0.28u
X134 start a_40508_12400# a_41708_12400# start nfet_03v3 ad=0.66p pd=3.64u as=0.305p ps=2.22u w=0.5u l=0.28u
X135 start start a_32694_49200# start nfet_03v3 ad=0.66p pd=3.64u as=0.305p ps=2.22u w=0.5u l=0.28u
X136 start a_44228_9464# a_43028_9464# start pfet_03v3 ad=1.38p pd=4.76u as=0.65p ps=3.3u w=1u l=0.28u
X137 start start a_4294_28400# start nfet_03v3 ad=0.66p pd=3.64u as=0.305p ps=2.22u w=0.5u l=0.28u
X138 start a_22108_15760# a_20908_15760# start pfet_03v3 ad=0.6034p pd=3.64u as=0.2822p ps=2.18u w=0.42u l=2u
X139 start a_2228_10824# a_2108_10960# start pfet_03v3 ad=1.38p pd=4.76u as=0.65p ps=3.3u w=1u l=0.28u
X140 a_3308_6160# a_2108_6160# a_4508_6160# start pfet_03v3 ad=0.65p pd=3.3u as=0.65p ps=3.3u w=1u l=0.28u
X141 start a_30228_54264# start start nfet_03v3 ad=0.2646p pd=2.1u as=0 ps=0 w=0.42u l=0.28u
X142 start comp_out_p comp_out_p start pfet_03v3 ad=1.38p pd=4.76u as=0.65p ps=3.3u w=1u l=0.28u
X143 start a_18508_29600# a_19708_29600# start pfet_03v3 ad=1.38p pd=4.76u as=0.65p ps=3.3u w=1u l=0.28u
X144 a_3308_20560# a_2108_20560# a_4508_20560# start pfet_03v3 ad=0.65p pd=3.3u as=0.65p ps=3.3u w=1u l=0.28u
X145 start a_48508_33600# a_50908_33600# start pfet_03v3 ad=1.38p pd=4.76u as=0.65p ps=3.3u w=1u l=0.28u
X146 start a_54908_12400# a_56108_12400# start pfet_03v3 ad=1.38p pd=4.76u as=0.65p ps=3.3u w=1u l=0.28u
X147 start a_3428_15624# a_3308_15760# start nfet_03v3 ad=0.66p pd=3.64u as=0.305p ps=2.22u w=0.5u l=0.28u
X148 start dac_in[5] dac_in[5] start pfet_03v3 ad=1.104p pd=4.36u as=0.52p ps=2.9u w=0.8u l=0.28u
X149 start a_61028_15064# a_59828_15064# start pfet_03v3 ad=1.38p pd=4.76u as=0.65p ps=3.3u w=1u l=0.28u
X150 start a_40628_9464# a_39428_9464# start nfet_03v3 ad=0.66p pd=3.64u as=0.305p ps=2.22u w=0.5u l=0.28u
X151 start comp_out_p a_4108_41600# start pfet_03v3 ad=1.38p pd=4.76u as=0.65p ps=3.3u w=1u l=0.28u
X152 a_20908_1360# start a_23308_1360# start pfet_03v3 ad=0.65p pd=3.3u as=0.65p ps=3.3u w=1u l=0.28u
X153 a_35494_40400# comp_out_p a_35308_41600# start nfet_03v3 ad=0.305p pd=2.22u as=0.305p ps=2.22u w=0.5u l=0.28u
X154 start a_58508_12400# a_59708_12400# start nfet_03v3 ad=0.66p pd=3.64u as=0.305p ps=2.22u w=0.5u l=0.28u
X155 start a_18508_33600# a_19894_32400# start nfet_03v3 ad=0.66p pd=3.64u as=0.305p ps=2.22u w=0.5u l=0.28u
X156 start a_13708_46000# a_14908_46000# start pfet_03v3 ad=1.38p pd=4.76u as=0.65p ps=3.3u w=1u l=0.28u
X157 start a_45428_3864# a_44228_3864# start nfet_03v3 ad=0.66p pd=3.64u as=0.305p ps=2.22u w=0.5u l=0.28u
X158 start a_37028_54264# a_36908_54400# start nfet_03v3 ad=0.577p pd=3.52u as=0.2646p ps=2.1u w=0.42u l=0.28u
X159 start a_11308_29600# a_12508_29600# start pfet_03v3 ad=1.38p pd=4.76u as=0.65p ps=3.3u w=1u l=0.28u
X160 start a_35308_29600# a_35308_29600# start pfet_03v3 ad=1.38p pd=4.76u as=0.65p ps=3.3u w=1u l=0.28u
X161 start a_44228_3864# a_43028_3864# start pfet_03v3 ad=1.38p pd=4.76u as=0.65p ps=3.3u w=1u l=0.28u
X162 start a_22108_6160# a_20908_6160# start nfet_03v3 ad=0.577p pd=3.52u as=0.2646p ps=2.1u w=0.42u l=2.4u
X163 start a_41308_33600# a_43708_33600# start pfet_03v3 ad=1.38p pd=4.76u as=0.65p ps=3.3u w=1u l=0.28u
X164 a_3308_15760# a_2108_15760# a_4508_15760# start pfet_03v3 ad=0.65p pd=3.3u as=0.65p ps=3.3u w=1u l=0.28u
X165 start start start start nfet_03v3 ad=0.305p pd=2.22u as=0 ps=0 w=0.5u l=0.28u
X166 start a_49028_9464# a_47828_9464# start pfet_03v3 ad=1.38p pd=4.76u as=0.65p ps=3.3u w=1u l=0.28u
X167 start start a_2908_37600# start pfet_03v3 ad=1.38p pd=4.76u as=0.65p ps=3.3u w=1u l=0.28u
X168 start a_2908_33600# a_10108_33600# start pfet_03v3 ad=1.104p pd=4.36u as=0.52p ps=2.9u w=0.8u l=0.28u
X169 start a_36908_1200# a_38108_1200# start nfet_03v3 ad=0.66p pd=3.64u as=0.305p ps=2.22u w=0.5u l=0.28u
X170 start a_20908_6160# a_22108_6160# start pfet_03v3 ad=1.38p pd=4.76u as=0.65p ps=3.3u w=1u l=0.28u
X171 start a_8108_6160# a_9308_6160# start pfet_03v3 ad=1.38p pd=4.76u as=0.65p ps=3.3u w=1u l=0.28u
X172 start a_49708_29600# a_51094_28400# start nfet_03v3 ad=0.66p pd=3.64u as=0.305p ps=2.22u w=0.5u l=0.28u
X173 start dac_in[6] dac_in[6] start pfet_03v3 ad=1.104p pd=4.36u as=0.52p ps=2.9u w=0.8u l=0.28u
X174 start a_4508_20560# a_5708_20560# start nfet_03v3 ad=0.66p pd=3.64u as=0.305p ps=2.22u w=0.5u l=0.28u
X175 start a_53828_15064# a_52628_15064# start pfet_03v3 ad=1.38p pd=4.76u as=0.65p ps=3.3u w=1u l=0.28u
X176 start a_50508_50400# a_50628_54264# start pfet_03v3 ad=1.38p pd=4.76u as=0.65p ps=3.3u w=1u l=0.28u
X177 start a_22108_10960# a_24508_10960# start nfet_03v3 ad=0.66p pd=3.64u as=0.305p ps=2.22u w=0.5u l=0.28u
X178 start a_11308_33600# a_12694_32400# start nfet_03v3 ad=0.66p pd=3.64u as=0.305p ps=2.22u w=0.5u l=0.28u
X179 start comp_out_p comp_out_p start nfet_03v3 ad=0.66p pd=3.64u as=0.305p ps=2.22u w=0.5u l=0.28u
X180 start a_50628_54264# a_50508_54400# start nfet_03v3 ad=0.577p pd=3.52u as=0.2646p ps=2.1u w=0.42u l=0.28u
X181 start a_34108_29600# a_41308_29600# start pfet_03v3 ad=1.104p pd=4.36u as=0.52p ps=2.9u w=0.8u l=0.28u
X182 a_43094_18000# start a_42908_19200# start nfet_03v3 ad=0.305p pd=2.22u as=0.305p ps=2.22u w=0.5u l=0.28u
X183 start a_56108_1200# a_57308_1200# start nfet_03v3 ad=0.66p pd=3.64u as=0.305p ps=2.22u w=0.5u l=0.28u
X184 start a_45428_9464# a_44228_9464# start nfet_03v3 ad=0.66p pd=3.64u as=0.305p ps=2.22u w=0.5u l=0.28u
X185 start a_19708_37600# dout[2] start pfet_03v3 ad=1.104p pd=4.36u as=0.52p ps=2.9u w=0.8u l=0.28u
X186 start a_24508_1360# a_23308_1360# start pfet_03v3 ad=0.6034p pd=3.64u as=0.2822p ps=2.18u w=0.42u l=2u
X187 start a_34628_9464# a_33428_9464# start pfet_03v3 ad=1.38p pd=4.76u as=0.65p ps=3.3u w=1u l=0.28u
X188 start a_49708_41600# a_50908_41600# start pfet_03v3 ad=1.38p pd=4.76u as=0.65p ps=3.3u w=1u l=0.28u
X189 start start a_2908_41600# start nfet_03v3 ad=0.66p pd=3.64u as=0.305p ps=2.22u w=0.5u l=0.28u
X190 start start a_4108_50400# start pfet_03v3 ad=1.104p pd=4.36u as=0.52p ps=2.9u w=0.8u l=0.28u
X191 start a_41708_12400# a_42908_12400# start pfet_03v3 ad=1.38p pd=4.76u as=0.65p ps=3.3u w=1u l=0.28u
X192 start a_49028_15064# a_47828_15064# start nfet_03v3 ad=0.66p pd=3.64u as=0.305p ps=2.22u w=0.5u l=0.28u
X193 start a_49028_3864# sample_en start pfet_03v3 ad=1.38p pd=4.76u as=0.65p ps=3.3u w=1u l=0.28u
X194 start a_5308_46000# a_6508_46000# start nfet_03v3 ad=0.66p pd=3.64u as=0.305p ps=2.22u w=0.5u l=0.28u
X195 start dout[0] a_11308_29600# start nfet_03v3 ad=0.577p pd=3.52u as=0.2646p ps=2.1u w=0.42u l=0.28u
X196 start a_46508_1200# a_47708_1200# start nfet_03v3 ad=0.66p pd=3.64u as=0.305p ps=2.22u w=0.5u l=0.28u
X197 start a_59828_9464# a_58628_9464# start pfet_03v3 ad=1.38p pd=4.76u as=0.65p ps=3.3u w=1u l=0.28u
X198 start a_34108_33600# a_41308_33600# start nfet_03v3 ad=0.577p pd=3.52u as=0.2646p ps=2.1u w=0.42u l=0.28u
X199 start a_10628_20424# a_9308_20560# start pfet_03v3 ad=1.38p pd=4.76u as=0.65p ps=3.3u w=1u l=0.28u
X200 start a_41708_6800# a_42908_6800# start pfet_03v3 ad=1.38p pd=4.76u as=0.65p ps=3.3u w=1u l=0.28u
X201 start a_19708_41600# dout[3] start nfet_03v3 ad=0.577p pd=3.52u as=0.2646p ps=2.1u w=0.42u l=0.28u
X202 start a_45308_12400# a_46508_12400# start nfet_03v3 ad=0.66p pd=3.64u as=0.305p ps=2.22u w=0.5u l=0.28u
X203 start a_9708_50400# a_9828_54264# start pfet_03v3 ad=1.38p pd=4.76u as=0.65p ps=3.3u w=1u l=0.28u
X204 start dout[3] a_23308_50400# start pfet_03v3 ad=1.104p pd=4.36u as=0.52p ps=2.9u w=0.8u l=0.28u
X205 a_24694_0# a_23308_1360# a_24508_1360# start nfet_03v3 ad=0.305p pd=2.22u as=0.305p ps=2.22u w=0.5u l=0.28u
X206 start start a_33308_24800# start nfet_03v3 ad=0.66p pd=3.64u as=0.305p ps=2.22u w=0.5u l=0.28u
X207 start a_5708_10960# a_4508_10960# start pfet_03v3 ad=0.6034p pd=3.64u as=0.2822p ps=2.18u w=0.42u l=2u
X208 start dac_in[4] dac_in[4] start nfet_03v3 ad=0.577p pd=3.52u as=0.2646p ps=2.1u w=0.42u l=0.28u
X209 a_46294_53200# a_43708_54400# dac_in[6] start nfet_03v3 ad=0.305p pd=2.22u as=0.305p ps=2.22u w=0.5u l=0.28u
X210 start a_8108_20560# a_9308_20560# start pfet_03v3 ad=1.38p pd=4.76u as=0.65p ps=3.3u w=1u l=0.28u
X211 start a_51428_15064# a_50228_15064# start nfet_03v3 ad=0.66p pd=3.64u as=0.305p ps=2.22u w=0.5u l=0.28u
X212 start a_35828_3864# a_34628_3864# start nfet_03v3 ad=0.66p pd=3.64u as=0.305p ps=2.22u w=0.5u l=0.28u
X213 start dout[3] a_11308_41600# start pfet_03v3 ad=1.104p pd=4.36u as=0.52p ps=2.9u w=0.8u l=0.28u
X214 a_5708_15760# a_2108_15760# a_8108_15760# start nfet_03v3 ad=0.305p pd=2.22u as=0.305p ps=2.22u w=0.5u l=0.28u
X215 start a_34628_3864# a_33428_3864# start pfet_03v3 ad=1.38p pd=4.76u as=0.65p ps=3.3u w=1u l=0.28u
X216 start a_34508_12400# a_35708_12400# start pfet_03v3 ad=1.38p pd=4.76u as=0.65p ps=3.3u w=1u l=0.28u
X217 start a_50908_37600# dout[6] start nfet_03v3 ad=0.577p pd=3.52u as=0.2646p ps=2.1u w=0.42u l=0.28u
X218 start a_39428_9464# a_38228_9464# start pfet_03v3 ad=1.38p pd=4.76u as=0.65p ps=3.3u w=1u l=0.28u
X219 start a_15028_10824# a_14908_10960# start pfet_03v3 ad=1.38p pd=4.76u as=0.65p ps=3.3u w=1u l=0.28u
X220 start dout[6] a_42508_37600# start pfet_03v3 ad=1.104p pd=4.36u as=0.52p ps=2.9u w=0.8u l=0.28u
X221 start a_10628_15624# a_9308_15760# start pfet_03v3 ad=1.38p pd=4.76u as=0.65p ps=3.3u w=1u l=0.28u
X222 start a_59828_3864# a_58628_3864# start pfet_03v3 ad=1.38p pd=4.76u as=0.65p ps=3.3u w=1u l=0.28u
X223 start a_16508_50400# a_16628_54264# start pfet_03v3 ad=1.38p pd=4.76u as=0.65p ps=3.3u w=1u l=0.28u
X224 start a_41708_1200# a_42908_1200# start pfet_03v3 ad=1.38p pd=4.76u as=0.65p ps=3.3u w=1u l=0.28u
X225 start a_16228_15624# a_16108_15760# start nfet_03v3 ad=0.66p pd=3.64u as=0.305p ps=2.22u w=0.5u l=0.28u
X226 start a_16628_54264# a_16508_54400# start nfet_03v3 ad=0.577p pd=3.52u as=0.2646p ps=2.1u w=0.42u l=0.28u
X227 start dout[0] a_18508_29600# start pfet_03v3 ad=1.104p pd=4.36u as=0.52p ps=2.9u w=0.8u l=0.28u
X228 start a_35828_9464# a_34628_9464# start nfet_03v3 ad=0.66p pd=3.64u as=0.305p ps=2.22u w=0.5u l=0.28u
X229 start comp_done a_2908_46000# start pfet_03v3 ad=1.38p pd=4.76u as=0.65p ps=3.3u w=1u l=0.28u
X230 start comp_out_p a_48508_33600# start pfet_03v3 ad=1.104p pd=4.36u as=0.52p ps=2.9u w=0.8u l=0.28u
X231 start a_8108_15760# a_9308_15760# start pfet_03v3 ad=1.38p pd=4.76u as=0.65p ps=3.3u w=1u l=0.28u
X232 start a_2228_1424# start start pfet_03v3 ad=0.52p pd=2.9u as=0 ps=0 w=0.8u l=0.28u
X233 start a_18628_1224# a_18508_1360# start pfet_03v3 ad=1.38p pd=4.76u as=0.65p ps=3.3u w=1u l=0.28u
X234 start a_52508_6800# a_53708_6800# start pfet_03v3 ad=1.38p pd=4.76u as=0.65p ps=3.3u w=1u l=0.28u
X235 start a_9308_20560# a_11708_20560# start nfet_03v3 ad=0.66p pd=3.64u as=0.305p ps=2.22u w=0.5u l=0.28u
X236 start a_12508_33600# dout[1] start pfet_03v3 ad=1.104p pd=4.36u as=0.52p ps=2.9u w=0.8u l=0.28u
X237 a_12694_36400# a_10108_37600# a_12508_37600# start nfet_03v3 ad=0.305p pd=2.22u as=0.305p ps=2.22u w=0.5u l=0.28u
X238 start dout[7] a_42508_41600# start nfet_03v3 ad=0.577p pd=3.52u as=0.2646p ps=2.1u w=0.42u l=0.28u
X239 start a_58628_15064# a_57428_15064# start pfet_03v3 ad=1.38p pd=4.76u as=0.65p ps=3.3u w=1u l=0.28u
X240 start a_39428_3864# a_38228_3864# start pfet_03v3 ad=1.38p pd=4.76u as=0.65p ps=3.3u w=1u l=0.28u
X241 start start a_30228_54264# start pfet_03v3 ad=1.38p pd=4.76u as=0.65p ps=3.3u w=1u l=0.28u
X242 start dout[6] a_43708_50400# start pfet_03v3 ad=1.104p pd=4.36u as=0.52p ps=2.9u w=0.8u l=0.28u
X243 start a_33428_12264# a_33308_12400# start nfet_03v3 ad=0.66p pd=3.64u as=0.305p ps=2.22u w=0.5u l=0.28u
X244 start a_3028_54264# a_2908_54400# start pfet_03v3 ad=1.104p pd=4.36u as=0.52p ps=2.9u w=0.8u l=0.28u
X245 start a_16628_54264# a_16628_54264# start pfet_03v3 ad=1.104p pd=4.36u as=0.52p ps=2.9u w=0.8u l=0.28u
X246 start a_42908_6800# a_44108_6800# start nfet_03v3 ad=0.66p pd=3.64u as=0.305p ps=2.22u w=0.5u l=0.28u
X247 start dac_in[7] dac_in[7] start nfet_03v3 ad=0.577p pd=3.52u as=0.2646p ps=2.1u w=0.42u l=0.28u
X248 start dout[1] a_18508_33600# start nfet_03v3 ad=0.577p pd=3.52u as=0.2646p ps=2.1u w=0.42u l=0.28u
X249 a_16108_6160# a_14908_6160# a_17308_6160# start pfet_03v3 ad=0.65p pd=3.3u as=0.65p ps=3.3u w=1u l=0.28u
X250 start a_33428_6664# a_33308_6800# start pfet_03v3 ad=1.38p pd=4.76u as=0.65p ps=3.3u w=1u l=0.28u
X251 start a_43708_29600# dout[4] start pfet_03v3 ad=1.104p pd=4.36u as=0.52p ps=2.9u w=0.8u l=0.28u
X252 a_16108_15760# a_14908_15760# a_17308_15760# start pfet_03v3 ad=0.65p pd=3.3u as=0.65p ps=3.3u w=1u l=0.28u
X253 start a_11308_46000# a_12508_46000# start nfet_03v3 ad=0.66p pd=3.64u as=0.305p ps=2.22u w=0.5u l=0.28u
X254 start a_47708_1200# a_48908_1200# start nfet_03v3 ad=0.66p pd=3.64u as=0.305p ps=2.22u w=0.5u l=0.28u
X255 start a_18508_10960# a_17308_10960# start nfet_03v3 ad=0.577p pd=3.52u as=0.2646p ps=2.1u w=0.42u l=2.4u
X256 start a_4108_54400# a_5494_53200# start nfet_03v3 ad=0.66p pd=3.64u as=0.305p ps=2.22u w=0.5u l=0.28u
X257 start dout[4] a_49708_29600# start nfet_03v3 ad=0.577p pd=3.52u as=0.2646p ps=2.1u w=0.42u l=0.28u
X258 start start start start pfet_03v3 ad=0.65p pd=3.3u as=0 ps=0 w=1u l=0.28u
X259 start a_52508_1200# a_53708_1200# start pfet_03v3 ad=1.38p pd=4.76u as=0.65p ps=3.3u w=1u l=0.28u
X260 start a_3428_1424# start start nfet_03v3 ad=0.305p pd=2.22u as=0 ps=0 w=0.5u l=0.28u
X261 start start a_10908_54400# start pfet_03v3 ad=1.104p pd=4.36u as=0.52p ps=2.9u w=0.8u l=0.28u
X262 start a_57308_6800# a_58508_6800# start pfet_03v3 ad=1.38p pd=4.76u as=0.65p ps=3.3u w=1u l=0.28u
X263 start a_9308_10960# a_8108_10960# start pfet_03v3 ad=0.6034p pd=3.64u as=0.2822p ps=2.18u w=0.42u l=2u
X264 start a_59708_12400# a_60908_12400# start nfet_03v3 ad=0.66p pd=3.64u as=0.305p ps=2.22u w=0.5u l=0.28u
X265 a_53094_49200# a_50508_50400# a_50628_54264# start nfet_03v3 ad=0.305p pd=2.22u as=0.305p ps=2.22u w=0.5u l=0.28u
X266 start a_43708_33600# dout[5] start nfet_03v3 ad=0.577p pd=3.52u as=0.2646p ps=2.1u w=0.42u l=0.28u
X267 start a_38108_1200# a_39308_1200# start nfet_03v3 ad=0.66p pd=3.64u as=0.305p ps=2.22u w=0.5u l=0.28u
X268 start a_23428_54264# a_23428_54264# start pfet_03v3 ad=1.104p pd=4.36u as=0.52p ps=2.9u w=0.8u l=0.28u
X269 start a_36908_50400# a_37028_54264# start pfet_03v3 ad=1.38p pd=4.76u as=0.65p ps=3.3u w=1u l=0.28u
X270 start dac_in[1] dac_in[1] start nfet_03v3 ad=0.577p pd=3.52u as=0.2646p ps=2.1u w=0.42u l=0.28u
X271 a_25894_53200# a_23308_54400# dac_in[3] start nfet_03v3 ad=0.305p pd=2.22u as=0.305p ps=2.22u w=0.5u l=0.28u
X272 start start a_4108_50400# start nfet_03v3 ad=0.577p pd=3.52u as=0.2646p ps=2.1u w=0.42u l=0.28u
X273 start a_17308_37600# a_19708_37600# start pfet_03v3 ad=1.38p pd=4.76u as=0.65p ps=3.3u w=1u l=0.28u
X274 start a_48908_12400# a_50108_12400# start pfet_03v3 ad=1.38p pd=4.76u as=0.65p ps=3.3u w=1u l=0.28u
X275 start a_56228_15064# a_55028_15064# start nfet_03v3 ad=0.66p pd=3.64u as=0.305p ps=2.22u w=0.5u l=0.28u
X276 start dout[7] a_49708_41600# start pfet_03v3 ad=1.104p pd=4.36u as=0.52p ps=2.9u w=0.8u l=0.28u
X277 start start a_33308_1200# start pfet_03v3 ad=1.38p pd=4.76u as=0.65p ps=3.3u w=1u l=0.28u
X278 start a_47708_6800# a_48908_6800# start nfet_03v3 ad=0.66p pd=3.64u as=0.305p ps=2.22u w=0.5u l=0.28u
X279 start comp_out_p comp_out_p start pfet_03v3 ad=1.38p pd=4.76u as=0.65p ps=3.3u w=1u l=0.28u
X280 start a_36908_6800# a_38108_6800# start pfet_03v3 ad=1.38p pd=4.76u as=0.65p ps=3.3u w=1u l=0.28u
X281 start a_57308_1200# a_58508_1200# start nfet_03v3 ad=0.66p pd=3.64u as=0.305p ps=2.22u w=0.5u l=0.28u
X282 start a_4508_6160# a_5708_6160# start nfet_03v3 ad=0.66p pd=3.64u as=0.305p ps=2.22u w=0.5u l=0.28u
X283 start a_2228_6024# a_2108_6160# start pfet_03v3 ad=1.38p pd=4.76u as=0.65p ps=3.3u w=1u l=0.28u
X284 start a_52508_12400# a_53708_12400# start nfet_03v3 ad=0.66p pd=3.64u as=0.305p ps=2.22u w=0.5u l=0.28u
X285 start a_37028_54264# a_37028_54264# start pfet_03v3 ad=1.104p pd=4.36u as=0.52p ps=2.9u w=0.8u l=0.28u
X286 start a_45428_15064# a_44228_15064# start pfet_03v3 ad=1.38p pd=4.76u as=0.65p ps=3.3u w=1u l=0.28u
X287 start dout[3] a_23308_50400# start nfet_03v3 ad=0.577p pd=3.52u as=0.2646p ps=2.1u w=0.42u l=0.28u
X288 a_12294_49200# a_9708_50400# a_9828_54264# start nfet_03v3 ad=0.305p pd=2.22u as=0.305p ps=2.22u w=0.5u l=0.28u
X289 a_19894_40400# a_17308_41600# a_19708_41600# start nfet_03v3 ad=0.305p pd=2.22u as=0.305p ps=2.22u w=0.5u l=0.28u
X290 start a_57308_1200# a_58508_1200# start pfet_03v3 ad=1.38p pd=4.76u as=0.65p ps=3.3u w=1u l=0.28u
X291 start a_33308_6800# a_34508_6800# start nfet_03v3 ad=0.66p pd=3.64u as=0.305p ps=2.22u w=0.5u l=0.28u
X292 a_3308_10960# a_2228_10824# a_4508_10960# start nfet_03v3 ad=0.305p pd=2.22u as=0.305p ps=2.22u w=0.5u l=0.28u
X293 start a_25828_1224# a_24694_0# start nfet_03v3 ad=0.66p pd=3.64u as=0.305p ps=2.22u w=0.5u l=0.28u
X294 start a_19708_1360# a_20908_1360# start pfet_03v3 ad=1.38p pd=4.76u as=0.65p ps=3.3u w=1u l=0.28u
X295 start a_17708_54400# dac_in[2] start pfet_03v3 ad=1.38p pd=4.76u as=0.65p ps=3.3u w=1u l=0.28u
X296 start start start start pfet_03v3 ad=0.52p pd=2.9u as=0 ps=0 w=0.8u l=0.28u
X297 start start a_35494_28400# start nfet_03v3 ad=0.66p pd=3.64u as=0.305p ps=2.22u w=0.5u l=0.28u
X298 start a_20908_10960# a_22108_10960# start pfet_03v3 ad=1.38p pd=4.76u as=0.65p ps=3.3u w=1u l=0.28u
X299 start comp_out_p a_17308_37600# start nfet_03v3 ad=0.577p pd=3.52u as=0.2646p ps=2.1u w=0.42u l=0.28u
X300 start start a_2908_33600# start pfet_03v3 ad=1.38p pd=4.76u as=0.65p ps=3.3u w=1u l=0.28u
X301 start a_36908_1200# a_38108_1200# start pfet_03v3 ad=1.38p pd=4.76u as=0.65p ps=3.3u w=1u l=0.28u
X302 start a_9308_6160# a_8108_6160# start nfet_03v3 ad=0.577p pd=3.52u as=0.2646p ps=2.1u w=0.42u l=2.4u
X303 start a_58508_6800# a_59708_6800# start nfet_03v3 ad=0.66p pd=3.64u as=0.305p ps=2.22u w=0.5u l=0.28u
X304 start a_43028_3864# a_41828_3864# start nfet_03v3 ad=0.66p pd=3.64u as=0.305p ps=2.22u w=0.5u l=0.28u
X305 start a_43828_54264# a_43828_54264# start pfet_03v3 ad=1.104p pd=4.36u as=0.52p ps=2.9u w=0.8u l=0.28u
X306 start a_23428_6024# a_22294_4800# start nfet_03v3 ad=0.66p pd=3.64u as=0.305p ps=2.22u w=0.5u l=0.28u
X307 start a_36908_12400# a_38108_12400# start nfet_03v3 ad=0.66p pd=3.64u as=0.305p ps=2.22u w=0.5u l=0.28u
X308 a_19094_49200# a_16508_50400# a_16628_54264# start nfet_03v3 ad=0.305p pd=2.22u as=0.305p ps=2.22u w=0.5u l=0.28u
X309 start a_23428_15624# a_22294_14400# start nfet_03v3 ad=0.66p pd=3.64u as=0.305p ps=2.22u w=0.5u l=0.28u
X310 start a_5708_6160# a_4508_6160# start pfet_03v3 ad=0.6034p pd=3.64u as=0.2822p ps=2.18u w=0.42u l=2u
X311 start a_52628_9464# a_51428_9464# start pfet_03v3 ad=1.38p pd=4.76u as=0.65p ps=3.3u w=1u l=0.28u
X312 start a_40908_24800# a_42294_23600# start nfet_03v3 ad=0.66p pd=3.64u as=0.305p ps=2.22u w=0.5u l=0.28u
X313 start a_16108_46000# a_17308_46000# start nfet_03v3 ad=0.66p pd=3.64u as=0.305p ps=2.22u w=0.5u l=0.28u
X314 start comp_out_p a_35308_41600# start pfet_03v3 ad=1.38p pd=4.76u as=0.65p ps=3.3u w=1u l=0.28u
X315 start a_19708_33600# dout[1] start pfet_03v3 ad=1.104p pd=4.36u as=0.52p ps=2.9u w=0.8u l=0.28u
X316 start start start start nfet_03v3 ad=0.305p pd=2.22u as=0 ps=0 w=0.5u l=0.28u
X317 start a_42508_37600# a_43894_36400# start nfet_03v3 ad=0.66p pd=3.64u as=0.305p ps=2.22u w=0.5u l=0.28u
X318 start a_38108_6800# a_39308_6800# start nfet_03v3 ad=0.66p pd=3.64u as=0.305p ps=2.22u w=0.5u l=0.28u
X319 a_9494_9600# a_8108_10960# a_9308_10960# start nfet_03v3 ad=0.305p pd=2.22u as=0.305p ps=2.22u w=0.5u l=0.28u
X320 a_22294_9600# a_20908_10960# a_22108_10960# start nfet_03v3 ad=0.305p pd=2.22u as=0.305p ps=2.22u w=0.5u l=0.28u
X321 start a_24508_54400# dac_in[3] start pfet_03v3 ad=1.38p pd=4.76u as=0.65p ps=3.3u w=1u l=0.28u
X322 start start a_38108_54400# start pfet_03v3 ad=1.104p pd=4.36u as=0.52p ps=2.9u w=0.8u l=0.28u
X323 start dout[6] a_43708_50400# start nfet_03v3 ad=0.577p pd=3.52u as=0.2646p ps=2.1u w=0.42u l=0.28u
X324 start a_43028_9464# a_41828_9464# start nfet_03v3 ad=0.66p pd=3.64u as=0.305p ps=2.22u w=0.5u l=0.28u
X325 start a_39308_12400# a_40508_12400# start nfet_03v3 ad=0.66p pd=3.64u as=0.305p ps=2.22u w=0.5u l=0.28u
X326 start a_16628_54264# a_16628_54264# start nfet_03v3 ad=0.577p pd=3.52u as=0.2646p ps=2.1u w=0.42u l=0.28u
X327 a_32694_49200# start a_30228_54264# start nfet_03v3 ad=0.305p pd=2.22u as=0.305p ps=2.22u w=0.5u l=0.28u
X328 start a_59708_6800# a_60908_6800# start pfet_03v3 ad=1.38p pd=4.76u as=0.65p ps=3.3u w=1u l=0.28u
X329 start a_50908_29600# dout[4] start pfet_03v3 ad=1.104p pd=4.36u as=0.52p ps=2.9u w=0.8u l=0.28u
X330 a_4294_28400# comp_out_p comp_out_p start nfet_03v3 ad=0.305p pd=2.22u as=0.305p ps=2.22u w=0.5u l=0.28u
X331 start a_22108_15760# a_24508_15760# start pfet_03v3 ad=1.38p pd=4.76u as=0.65p ps=3.3u w=1u l=0.28u
X332 start start a_34108_37600# start pfet_03v3 ad=1.38p pd=4.76u as=0.65p ps=3.3u w=1u l=0.28u
X333 start a_3428_20424# a_3308_20560# start pfet_03v3 ad=1.38p pd=4.76u as=0.65p ps=3.3u w=1u l=0.28u
X334 start a_18508_46000# a_19708_46000# start pfet_03v3 ad=1.38p pd=4.76u as=0.65p ps=3.3u w=1u l=0.28u
X335 start start start start pfet_03v3 ad=0.65p pd=3.3u as=0 ps=0 w=1u l=0.28u
X336 start a_2228_15624# a_2108_15760# start nfet_03v3 ad=0.66p pd=3.64u as=0.305p ps=2.22u w=0.5u l=0.28u
X337 start a_53828_3864# a_52628_3864# start nfet_03v3 ad=0.66p pd=3.64u as=0.305p ps=2.22u w=0.5u l=0.28u
X338 start a_53708_12400# a_54908_12400# start pfet_03v3 ad=1.38p pd=4.76u as=0.65p ps=3.3u w=1u l=0.28u
X339 start a_52628_3864# a_51428_3864# start pfet_03v3 ad=1.38p pd=4.76u as=0.65p ps=3.3u w=1u l=0.28u
X340 start a_38108_54400# dac_in[5] start pfet_03v3 ad=1.38p pd=4.76u as=0.65p ps=3.3u w=1u l=0.28u
X341 start start a_51708_54400# start pfet_03v3 ad=1.104p pd=4.36u as=0.52p ps=2.9u w=0.8u l=0.28u
X342 start comp_out_p comp_out_p start pfet_03v3 ad=1.38p pd=4.76u as=0.65p ps=3.3u w=1u l=0.28u
X343 start comp_done a_42908_19200# start pfet_03v3 ad=1.38p pd=4.76u as=0.65p ps=3.3u w=1u l=0.28u
X344 start a_57428_9464# a_56228_9464# start pfet_03v3 ad=1.38p pd=4.76u as=0.65p ps=3.3u w=1u l=0.28u
X345 start comp_out_p a_4108_41600# start pfet_03v3 ad=1.38p pd=4.76u as=0.65p ps=3.3u w=1u l=0.28u
X346 start a_50908_33600# dout[5] start nfet_03v3 ad=0.577p pd=3.52u as=0.2646p ps=2.1u w=0.42u l=0.28u
X347 start start a_34108_41600# start nfet_03v3 ad=0.66p pd=3.64u as=0.305p ps=2.22u w=0.5u l=0.28u
X348 start a_57308_12400# a_58508_12400# start nfet_03v3 ad=0.66p pd=3.64u as=0.305p ps=2.22u w=0.5u l=0.28u
X349 a_39494_49200# a_36908_50400# a_37028_54264# start nfet_03v3 ad=0.305p pd=2.22u as=0.305p ps=2.22u w=0.5u l=0.28u
X350 start a_23428_54264# a_23428_54264# start nfet_03v3 ad=0.577p pd=3.52u as=0.2646p ps=2.1u w=0.42u l=0.28u
X351 start a_24508_1360# a_26908_1360# start nfet_03v3 ad=0.66p pd=3.64u as=0.305p ps=2.22u w=0.5u l=0.28u
X352 start a_33428_3864# a_33308_4000# start nfet_03v3 ad=0.66p pd=3.64u as=0.305p ps=2.22u w=0.5u l=0.28u
X353 start a_4108_41600# a_7708_41600# start nfet_03v3 ad=0.66p pd=3.64u as=0.305p ps=2.22u w=0.5u l=0.28u
X354 start a_10108_29600# a_12508_29600# start pfet_03v3 ad=1.38p pd=4.76u as=0.65p ps=3.3u w=1u l=0.28u
X355 start a_59708_1200# a_60908_1200# start pfet_03v3 ad=1.38p pd=4.76u as=0.65p ps=3.3u w=1u l=0.28u
X356 start dout[5] a_42508_33600# start pfet_03v3 ad=1.104p pd=4.36u as=0.52p ps=2.9u w=0.8u l=0.28u
X357 start a_3428_15624# a_3308_15760# start pfet_03v3 ad=1.38p pd=4.76u as=0.65p ps=3.3u w=1u l=0.28u
X358 start a_53828_9464# a_52628_9464# start nfet_03v3 ad=0.66p pd=3.64u as=0.305p ps=2.22u w=0.5u l=0.28u
X359 start a_37028_9464# a_35828_9464# start pfet_03v3 ad=1.38p pd=4.76u as=0.65p ps=3.3u w=1u l=0.28u
X360 start a_46508_12400# a_47708_12400# start pfet_03v3 ad=1.38p pd=4.76u as=0.65p ps=3.3u w=1u l=0.28u
X361 a_51094_28400# a_48508_29600# a_50908_29600# start nfet_03v3 ad=0.305p pd=2.22u as=0.305p ps=2.22u w=0.5u l=0.28u
X362 start start start start pfet_03v3 ad=0.52p pd=2.9u as=0 ps=0 w=0.8u l=0.28u
X363 start a_44908_54400# dac_in[6] start pfet_03v3 ad=1.38p pd=4.76u as=0.65p ps=3.3u w=1u l=0.28u
X364 a_3308_20560# a_2228_20424# a_4508_20560# start nfet_03v3 ad=0.305p pd=2.22u as=0.305p ps=2.22u w=0.5u l=0.28u
X365 start a_52628_15064# a_51428_15064# start pfet_03v3 ad=1.38p pd=4.76u as=0.65p ps=3.3u w=1u l=0.28u
X366 start a_58628_3864# a_57428_3864# start nfet_03v3 ad=0.66p pd=3.64u as=0.305p ps=2.22u w=0.5u l=0.28u
X367 start start a_17308_1360# start nfet_03v3 ad=0.66p pd=3.64u as=0.305p ps=2.22u w=0.5u l=0.28u
X368 start a_37028_54264# a_37028_54264# start nfet_03v3 ad=0.577p pd=3.52u as=0.2646p ps=2.1u w=0.42u l=0.28u
X369 start a_57428_3864# a_56228_3864# start pfet_03v3 ad=1.38p pd=4.76u as=0.65p ps=3.3u w=1u l=0.28u
X370 start a_58508_1200# a_59708_1200# start nfet_03v3 ad=0.66p pd=3.64u as=0.305p ps=2.22u w=0.5u l=0.28u
X371 start comp_out_p a_4294_36400# start nfet_03v3 ad=0.66p pd=3.64u as=0.305p ps=2.22u w=0.5u l=0.28u
X372 a_12694_32400# a_10108_33600# a_12508_33600# start nfet_03v3 ad=0.305p pd=2.22u as=0.305p ps=2.22u w=0.5u l=0.28u
X373 start a_9828_54264# a_9708_54400# start pfet_03v3 ad=1.104p pd=4.36u as=0.52p ps=2.9u w=0.8u l=0.28u
X374 start a_50108_6800# a_51308_6800# start pfet_03v3 ad=1.38p pd=4.76u as=0.65p ps=3.3u w=1u l=0.28u
X375 start a_33428_9464# a_33308_9600# start nfet_03v3 ad=0.66p pd=3.64u as=0.305p ps=2.22u w=0.5u l=0.28u
X376 start a_18508_37600# a_19708_37600# start pfet_03v3 ad=1.38p pd=4.76u as=0.65p ps=3.3u w=1u l=0.28u
X377 start dout[0] a_2908_50400# start pfet_03v3 ad=1.104p pd=4.36u as=0.52p ps=2.9u w=0.8u l=0.28u
X378 start a_48508_41600# a_50908_41600# start pfet_03v3 ad=1.38p pd=4.76u as=0.65p ps=3.3u w=1u l=0.28u
X379 start a_33308_24800# a_35894_23600# start nfet_03v3 ad=0.66p pd=3.64u as=0.305p ps=2.22u w=0.5u l=0.28u
X380 start a_38228_3864# a_37028_3864# start nfet_03v3 ad=0.66p pd=3.64u as=0.305p ps=2.22u w=0.5u l=0.28u
X381 a_43894_28400# a_41308_29600# a_43708_29600# start nfet_03v3 ad=0.305p pd=2.22u as=0.305p ps=2.22u w=0.5u l=0.28u
X382 start a_37028_3864# a_35828_3864# start pfet_03v3 ad=1.38p pd=4.76u as=0.65p ps=3.3u w=1u l=0.28u
X383 start a_17308_6160# a_18508_6160# start nfet_03v3 ad=0.66p pd=3.64u as=0.305p ps=2.22u w=0.5u l=0.28u
X384 start a_4108_46000# a_5308_46000# start nfet_03v3 ad=0.66p pd=3.64u as=0.305p ps=2.22u w=0.5u l=0.28u
X385 start a_2908_29600# a_10108_29600# start nfet_03v3 ad=0.577p pd=3.52u as=0.2646p ps=2.1u w=0.42u l=0.28u
X386 start a_10628_6024# a_9308_6160# start pfet_03v3 ad=1.38p pd=4.76u as=0.65p ps=3.3u w=1u l=0.28u
X387 start a_58628_9464# a_57428_9464# start nfet_03v3 ad=0.66p pd=3.64u as=0.305p ps=2.22u w=0.5u l=0.28u
X388 start start a_17708_54400# start pfet_03v3 ad=1.104p pd=4.36u as=0.52p ps=2.9u w=0.8u l=0.28u
X389 start a_47828_9464# a_46628_9464# start pfet_03v3 ad=1.38p pd=4.76u as=0.65p ps=3.3u w=1u l=0.28u
X390 start a_18508_10960# a_17308_10960# start pfet_03v3 ad=0.6034p pd=3.64u as=0.2822p ps=2.18u w=0.42u l=2u
X391 start a_18508_41600# a_19894_40400# start nfet_03v3 ad=0.66p pd=3.64u as=0.305p ps=2.22u w=0.5u l=0.28u
X392 start a_15028_6024# a_14908_6160# start pfet_03v3 ad=1.38p pd=4.76u as=0.65p ps=3.3u w=1u l=0.28u
X393 start a_44108_12400# a_45308_12400# start nfet_03v3 ad=0.66p pd=3.64u as=0.305p ps=2.22u w=0.5u l=0.28u
X394 start a_43828_54264# a_43828_54264# start nfet_03v3 ad=0.577p pd=3.52u as=0.2646p ps=2.1u w=0.42u l=0.28u
X395 start comp_out_p a_10908_50400# start pfet_03v3 ad=1.104p pd=4.36u as=0.52p ps=2.9u w=0.8u l=0.28u
X396 start start a_44908_54400# start nfet_03v3 ad=0.577p pd=3.52u as=0.2646p ps=2.1u w=0.42u l=0.28u
X397 start a_11308_37600# a_12508_37600# start pfet_03v3 ad=1.38p pd=4.76u as=0.65p ps=3.3u w=1u l=0.28u
X398 start comp_out_p comp_out_p start pfet_03v3 ad=1.38p pd=4.76u as=0.65p ps=3.3u w=1u l=0.28u
X399 a_5708_20560# a_2228_20424# a_8108_20560# start pfet_03v3 ad=0.65p pd=3.3u as=0.65p ps=3.3u w=1u l=0.28u
X400 start a_50228_15064# a_49028_15064# start nfet_03v3 ad=0.66p pd=3.64u as=0.305p ps=2.22u w=0.5u l=0.28u
X401 start a_41308_41600# a_43708_41600# start pfet_03v3 ad=1.38p pd=4.76u as=0.65p ps=3.3u w=1u l=0.28u
X402 a_16108_10960# a_15028_10824# a_17308_10960# start nfet_03v3 ad=0.305p pd=2.22u as=0.305p ps=2.22u w=0.5u l=0.28u
X403 start a_6508_46000# a_7708_46000# start pfet_03v3 ad=1.38p pd=4.76u as=0.65p ps=3.3u w=1u l=0.28u
X404 start a_50108_1200# a_51308_1200# start pfet_03v3 ad=1.38p pd=4.76u as=0.65p ps=3.3u w=1u l=0.28u
X405 start a_38228_9464# a_37028_9464# start nfet_03v3 ad=0.66p pd=3.64u as=0.305p ps=2.22u w=0.5u l=0.28u
X406 start a_33308_12400# a_34508_12400# start pfet_03v3 ad=1.38p pd=4.76u as=0.65p ps=3.3u w=1u l=0.28u
X407 start a_2908_41600# a_10108_41600# start pfet_03v3 ad=1.104p pd=4.36u as=0.52p ps=2.9u w=0.8u l=0.28u
X408 start a_5708_15760# a_4508_15760# start nfet_03v3 ad=0.577p pd=3.52u as=0.2646p ps=2.1u w=0.42u l=2.4u
X409 start a_54908_6800# a_56108_6800# start pfet_03v3 ad=1.38p pd=4.76u as=0.65p ps=3.3u w=1u l=0.28u
X410 start a_49708_37600# a_51094_36400# start nfet_03v3 ad=0.66p pd=3.64u as=0.305p ps=2.22u w=0.5u l=0.28u
X411 start a_17308_33600# a_19708_33600# start pfet_03v3 ad=1.38p pd=4.76u as=0.65p ps=3.3u w=1u l=0.28u
X412 start start start start nfet_03v3 ad=0.2646p pd=2.1u as=0 ps=0 w=0.42u l=2.4u
X413 start a_11308_41600# a_12694_40400# start nfet_03v3 ad=0.66p pd=3.64u as=0.305p ps=2.22u w=0.5u l=0.28u
X414 start a_35308_41600# a_38908_41600# start nfet_03v3 ad=0.66p pd=3.64u as=0.305p ps=2.22u w=0.5u l=0.28u
X415 start dac_in[0] dac_in[0] start pfet_03v3 ad=1.104p pd=4.36u as=0.52p ps=2.9u w=0.8u l=0.28u
X416 start a_34108_37600# a_41308_37600# start pfet_03v3 ad=1.104p pd=4.36u as=0.52p ps=2.9u w=0.8u l=0.28u
X417 start sample_en a_46628_3864# start pfet_03v3 ad=1.38p pd=4.76u as=0.65p ps=3.3u w=1u l=0.28u
X418 start a_15028_15624# a_14908_15760# start nfet_03v3 ad=0.66p pd=3.64u as=0.305p ps=2.22u w=0.5u l=0.28u
X419 start a_51308_6800# a_52508_6800# start nfet_03v3 ad=0.66p pd=3.64u as=0.305p ps=2.22u w=0.5u l=0.28u
X420 start comp_out_p a_17308_29600# start pfet_03v3 ad=1.104p pd=4.36u as=0.52p ps=2.9u w=0.8u l=0.28u
X421 start a_3428_6024# a_3308_6160# start nfet_03v3 ad=0.66p pd=3.64u as=0.305p ps=2.22u w=0.5u l=0.28u
X422 start a_22108_6160# a_20908_6160# start pfet_03v3 ad=0.6034p pd=3.64u as=0.2822p ps=2.18u w=0.42u l=2u
X423 start a_40508_6800# a_41708_6800# start pfet_03v3 ad=1.38p pd=4.76u as=0.65p ps=3.3u w=1u l=0.28u
X424 start a_10628_20424# a_9494_19200# start nfet_03v3 ad=0.66p pd=3.64u as=0.305p ps=2.22u w=0.5u l=0.28u
X425 a_5708_15760# a_2228_15624# a_8108_15760# start pfet_03v3 ad=0.65p pd=3.3u as=0.65p ps=3.3u w=1u l=0.28u
X426 start dout[2] a_11308_37600# start nfet_03v3 ad=0.577p pd=3.52u as=0.2646p ps=2.1u w=0.42u l=0.28u
X427 start a_54908_1200# a_56108_1200# start pfet_03v3 ad=1.38p pd=4.76u as=0.65p ps=3.3u w=1u l=0.28u
X428 start a_34108_41600# a_41308_41600# start nfet_03v3 ad=0.577p pd=3.52u as=0.2646p ps=2.1u w=0.42u l=0.28u
X429 a_9494_19200# a_8108_20560# a_9308_20560# start nfet_03v3 ad=0.305p pd=2.22u as=0.305p ps=2.22u w=0.5u l=0.28u
X430 start a_57428_15064# a_56228_15064# start pfet_03v3 ad=1.38p pd=4.76u as=0.65p ps=3.3u w=1u l=0.28u
X431 start a_17708_50400# a_16628_54264# start pfet_03v3 ad=1.38p pd=4.76u as=0.65p ps=3.3u w=1u l=0.28u
X432 start start start start pfet_03v3 ad=0.52p pd=2.9u as=0 ps=0 w=0.8u l=0.28u
X433 start a_61028_3864# a_59828_3864# start nfet_03v3 ad=0.66p pd=3.64u as=0.305p ps=2.22u w=0.5u l=0.28u
X434 start a_19708_46000# a_20908_46000# start pfet_03v3 ad=1.38p pd=4.76u as=0.65p ps=3.3u w=1u l=0.28u
X435 start comp_out_p a_17308_33600# start nfet_03v3 ad=0.577p pd=3.52u as=0.2646p ps=2.1u w=0.42u l=0.28u
X436 start a_2228_10824# a_2108_10960# start nfet_03v3 ad=0.66p pd=3.64u as=0.305p ps=2.22u w=0.5u l=0.28u
X437 start a_51708_54400# a_53094_53200# start nfet_03v3 ad=0.66p pd=3.64u as=0.305p ps=2.22u w=0.5u l=0.28u
X438 start a_42508_29600# a_43708_29600# start pfet_03v3 ad=1.38p pd=4.76u as=0.65p ps=3.3u w=1u l=0.28u
X439 start a_16228_15624# a_16108_15760# start pfet_03v3 ad=1.38p pd=4.76u as=0.65p ps=3.3u w=1u l=0.28u
X440 start a_10108_46000# a_11308_46000# start nfet_03v3 ad=0.66p pd=3.64u as=0.305p ps=2.22u w=0.5u l=0.28u
X441 a_5494_53200# a_2908_54400# dac_in[0] start nfet_03v3 ad=0.305p pd=2.22u as=0.305p ps=2.22u w=0.5u l=0.28u
X442 start a_47028_19064# done start pfet_03v3 ad=1.38p pd=4.76u as=0.65p ps=3.3u w=1u l=0.28u
X443 start a_40508_1200# a_41708_1200# start pfet_03v3 ad=1.38p pd=4.76u as=0.65p ps=3.3u w=1u l=0.28u
X444 start a_24508_1360# a_23308_1360# start nfet_03v3 ad=0.577p pd=3.52u as=0.2646p ps=2.1u w=0.42u l=2.4u
X445 start a_56108_6800# a_57308_6800# start nfet_03v3 ad=0.66p pd=3.64u as=0.305p ps=2.22u w=0.5u l=0.28u
X446 start a_35308_29600# a_48508_29600# start nfet_03v3 ad=0.577p pd=3.52u as=0.2646p ps=2.1u w=0.42u l=0.28u
X447 a_5708_6160# a_2108_6160# a_8108_6160# start nfet_03v3 ad=0.305p pd=2.22u as=0.305p ps=2.22u w=0.5u l=0.28u
X448 start a_45308_6800# a_46508_6800# start pfet_03v3 ad=1.38p pd=4.76u as=0.65p ps=3.3u w=1u l=0.28u
X449 start a_12508_29600# dout[0] start nfet_03v3 ad=0.577p pd=3.52u as=0.2646p ps=2.1u w=0.42u l=0.28u
X450 a_18508_6160# a_14908_6160# a_20908_6160# start nfet_03v3 ad=0.305p pd=2.22u as=0.305p ps=2.22u w=0.5u l=0.28u
X451 start a_42508_33600# a_43894_32400# start nfet_03v3 ad=0.66p pd=3.64u as=0.305p ps=2.22u w=0.5u l=0.28u
X452 start a_61028_9464# a_59828_9464# start nfet_03v3 ad=0.66p pd=3.64u as=0.305p ps=2.22u w=0.5u l=0.28u
X453 start a_50228_9464# a_49028_9464# start pfet_03v3 ad=1.38p pd=4.76u as=0.65p ps=3.3u w=1u l=0.28u
X454 start a_24508_50400# a_23428_54264# start pfet_03v3 ad=1.38p pd=4.76u as=0.65p ps=3.3u w=1u l=0.28u
X455 start a_35308_29600# a_38108_50400# start pfet_03v3 ad=1.104p pd=4.36u as=0.52p ps=2.9u w=0.8u l=0.28u
X456 start a_12508_46000# a_13708_46000# start pfet_03v3 ad=1.38p pd=4.76u as=0.65p ps=3.3u w=1u l=0.28u
X457 start a_9308_15760# a_8108_15760# start nfet_03v3 ad=0.577p pd=3.52u as=0.2646p ps=2.1u w=0.42u l=2.4u
X458 start a_18628_1224# a_18508_1360# start nfet_03v3 ad=0.66p pd=3.64u as=0.305p ps=2.22u w=0.5u l=0.28u
X459 start start a_24508_54400# start nfet_03v3 ad=0.577p pd=3.52u as=0.2646p ps=2.1u w=0.42u l=0.28u
X460 start a_10908_54400# a_12294_53200# start nfet_03v3 ad=0.66p pd=3.64u as=0.305p ps=2.22u w=0.5u l=0.28u
X461 start dout[0] a_2908_50400# start nfet_03v3 ad=0.577p pd=3.52u as=0.2646p ps=2.1u w=0.42u l=0.28u
X462 start dout[2] a_18508_37600# start pfet_03v3 ad=1.104p pd=4.36u as=0.52p ps=2.9u w=0.8u l=0.28u
X463 start a_55028_15064# a_53828_15064# start nfet_03v3 ad=0.66p pd=3.64u as=0.305p ps=2.22u w=0.5u l=0.28u
X464 start a_38908_41600# a_48508_41600# start pfet_03v3 ad=1.104p pd=4.36u as=0.52p ps=2.9u w=0.8u l=0.28u
X465 start start a_34108_33600# start pfet_03v3 ad=1.38p pd=4.76u as=0.65p ps=3.3u w=1u l=0.28u
X466 start a_35708_6800# a_36908_6800# start nfet_03v3 ad=0.66p pd=3.64u as=0.305p ps=2.22u w=0.5u l=0.28u
X467 start a_5708_10960# a_4508_10960# start nfet_03v3 ad=0.577p pd=3.52u as=0.2646p ps=2.1u w=0.42u l=2.4u
X468 start a_12508_41600# dout[3] start pfet_03v3 ad=1.104p pd=4.36u as=0.52p ps=2.9u w=0.8u l=0.28u
X469 start a_38108_12400# a_39308_12400# start pfet_03v3 ad=1.38p pd=4.76u as=0.65p ps=3.3u w=1u l=0.28u
X470 start comp_out_p comp_out_p start pfet_03v3 ad=1.38p pd=4.76u as=0.65p ps=3.3u w=1u l=0.28u
X471 start a_38108_50400# a_37028_54264# start pfet_03v3 ad=1.38p pd=4.76u as=0.65p ps=3.3u w=1u l=0.28u
X472 start comp_out_p a_51708_50400# start pfet_03v3 ad=1.104p pd=4.36u as=0.52p ps=2.9u w=0.8u l=0.28u
X473 start done a_33308_24800# start pfet_03v3 ad=1.38p pd=4.76u as=0.65p ps=3.3u w=1u l=0.28u
X474 start rst_latch rst_latch start pfet_03v3 ad=1.104p pd=4.36u as=0.52p ps=2.9u w=0.8u l=0.28u
X475 start a_44228_15064# a_44108_15200# start pfet_03v3 ad=1.38p pd=4.76u as=0.65p ps=3.3u w=1u l=0.28u
X476 start a_51308_12400# a_52508_12400# start nfet_03v3 ad=0.66p pd=3.64u as=0.305p ps=2.22u w=0.5u l=0.28u
X477 start comp_out_p a_10908_50400# start nfet_03v3 ad=0.577p pd=3.52u as=0.2646p ps=2.1u w=0.42u l=0.28u
X478 start dout[3] a_18508_41600# start nfet_03v3 ad=0.577p pd=3.52u as=0.2646p ps=2.1u w=0.42u l=0.28u
X479 start a_45308_1200# a_46508_1200# start pfet_03v3 ad=1.38p pd=4.76u as=0.65p ps=3.3u w=1u l=0.28u
X480 start a_43708_37600# dout[6] start pfet_03v3 ad=1.104p pd=4.36u as=0.52p ps=2.9u w=0.8u l=0.28u
X481 start start start start pfet_03v3 ad=0.65p pd=3.3u as=0 ps=0 w=1u l=0.28u
X482 start a_51428_3864# a_50228_3864# start nfet_03v3 ad=0.66p pd=3.64u as=0.305p ps=2.22u w=0.5u l=0.28u
X483 start a_50228_3864# a_49028_3864# start pfet_03v3 ad=1.38p pd=4.76u as=0.65p ps=3.3u w=1u l=0.28u
X484 start a_55028_9464# a_53828_9464# start pfet_03v3 ad=1.38p pd=4.76u as=0.65p ps=3.3u w=1u l=0.28u
X485 start a_40508_12400# a_41708_12400# start pfet_03v3 ad=1.38p pd=4.76u as=0.65p ps=3.3u w=1u l=0.28u
X486 start a_47828_15064# a_46628_15064# start nfet_03v3 ad=0.66p pd=3.64u as=0.305p ps=2.22u w=0.5u l=0.28u
X487 start start comp_out_p start pfet_03v3 ad=1.38p pd=4.76u as=0.65p ps=3.3u w=1u l=0.28u
X488 start a_30228_54264# start start pfet_03v3 ad=0.52p pd=2.9u as=0 ps=0 w=0.8u l=0.28u
X489 start dout[6] a_49708_37600# start nfet_03v3 ad=0.577p pd=3.52u as=0.2646p ps=2.1u w=0.42u l=0.28u
X490 a_35494_28400# comp_out_p a_35308_29600# start nfet_03v3 ad=0.305p pd=2.22u as=0.305p ps=2.22u w=0.5u l=0.28u
X491 a_18508_10960# a_15028_10824# a_20908_10960# start pfet_03v3 ad=0.65p pd=3.3u as=0.65p ps=3.3u w=1u l=0.28u
X492 start a_43708_41600# dout[7] start nfet_03v3 ad=0.577p pd=3.52u as=0.2646p ps=2.1u w=0.42u l=0.28u
X493 start a_46508_6800# a_47708_6800# start nfet_03v3 ad=0.66p pd=3.64u as=0.305p ps=2.22u w=0.5u l=0.28u
X494 start a_44908_50400# a_43828_54264# start pfet_03v3 ad=1.38p pd=4.76u as=0.65p ps=3.3u w=1u l=0.28u
X495 start a_35708_12400# a_36908_12400# start nfet_03v3 ad=0.66p pd=3.64u as=0.305p ps=2.22u w=0.5u l=0.28u
X496 start a_4508_10960# a_5708_10960# start pfet_03v3 ad=1.38p pd=4.76u as=0.65p ps=3.3u w=1u l=0.28u
X497 start a_51428_9464# a_50228_9464# start nfet_03v3 ad=0.66p pd=3.64u as=0.305p ps=2.22u w=0.5u l=0.28u
X498 a_22294_14400# a_20908_15760# a_22108_15760# start nfet_03v3 ad=0.305p pd=2.22u as=0.305p ps=2.22u w=0.5u l=0.28u
X499 start start a_32694_53200# start nfet_03v3 ad=0.66p pd=3.64u as=0.305p ps=2.22u w=0.5u l=0.28u
X500 a_10694_0# start start start nfet_03v3 ad=0.305p pd=2.22u as=0.305p ps=2.22u w=0.5u l=0.28u
X501 start a_40628_9464# a_39428_9464# start pfet_03v3 ad=1.38p pd=4.76u as=0.65p ps=3.3u w=1u l=0.28u
X502 start comp_out_p a_4294_32400# start nfet_03v3 ad=0.66p pd=3.64u as=0.305p ps=2.22u w=0.5u l=0.28u
X503 a_42294_23600# a_39708_24800# rst_latch start nfet_03v3 ad=0.305p pd=2.22u as=0.305p ps=2.22u w=0.5u l=0.28u
X504 start start start start nfet_03v3 ad=0.305p pd=2.22u as=0 ps=0 w=0.5u l=0.28u
X505 start dout[1] a_9708_50400# start pfet_03v3 ad=1.104p pd=4.36u as=0.52p ps=2.9u w=0.8u l=0.28u
X506 start comp_out_p a_35308_41600# start pfet_03v3 ad=1.38p pd=4.76u as=0.65p ps=3.3u w=1u l=0.28u
X507 start start start start pfet_03v3 ad=0.65p pd=3.3u as=0 ps=0 w=1u l=0.28u
X508 start a_58508_12400# a_59708_12400# start pfet_03v3 ad=1.38p pd=4.76u as=0.65p ps=3.3u w=1u l=0.28u
X509 start a_14908_46000# a_16108_46000# start nfet_03v3 ad=0.66p pd=3.64u as=0.305p ps=2.22u w=0.5u l=0.28u
X510 start a_18508_33600# a_19708_33600# start pfet_03v3 ad=1.38p pd=4.76u as=0.65p ps=3.3u w=1u l=0.28u
X511 start a_56228_3864# a_55028_3864# start nfet_03v3 ad=0.66p pd=3.64u as=0.305p ps=2.22u w=0.5u l=0.28u
X512 start a_55028_3864# a_53828_3864# start pfet_03v3 ad=1.38p pd=4.76u as=0.65p ps=3.3u w=1u l=0.28u
X513 start a_37028_54264# a_36908_54400# start pfet_03v3 ad=1.104p pd=4.36u as=0.52p ps=2.9u w=0.8u l=0.28u
X514 start start start start nfet_03v3 ad=0.2646p pd=2.1u as=0 ps=0 w=0.42u l=0.28u
X515 start a_17708_50400# a_19094_49200# start nfet_03v3 ad=0.66p pd=3.64u as=0.305p ps=2.22u w=0.5u l=0.28u
X516 start start a_2908_29600# start nfet_03v3 ad=0.66p pd=3.64u as=0.305p ps=2.22u w=0.5u l=0.28u
X517 start comp_out_p a_17708_50400# start pfet_03v3 ad=1.104p pd=4.36u as=0.52p ps=2.9u w=0.8u l=0.28u
X518 start a_49708_29600# a_50908_29600# start pfet_03v3 ad=1.38p pd=4.76u as=0.65p ps=3.3u w=1u l=0.28u
X519 start a_23428_15624# a_22108_15760# start pfet_03v3 ad=1.38p pd=4.76u as=0.65p ps=3.3u w=1u l=0.28u
X520 start a_17308_46000# a_18508_46000# start pfet_03v3 ad=1.38p pd=4.76u as=0.65p ps=3.3u w=1u l=0.28u
X521 start a_2228_20424# a_2108_20560# start pfet_03v3 ad=1.38p pd=4.76u as=0.65p ps=3.3u w=1u l=0.28u
X522 start a_9308_6160# a_11708_6160# start nfet_03v3 ad=0.66p pd=3.64u as=0.305p ps=2.22u w=0.5u l=0.28u
X523 start a_41828_3864# a_40628_3864# start nfet_03v3 ad=0.66p pd=3.64u as=0.305p ps=2.22u w=0.5u l=0.28u
X524 start a_16228_6024# a_16108_6160# start nfet_03v3 ad=0.66p pd=3.64u as=0.305p ps=2.22u w=0.5u l=0.28u
X525 start a_11308_33600# a_12508_33600# start pfet_03v3 ad=1.38p pd=4.76u as=0.65p ps=3.3u w=1u l=0.28u
X526 start comp_out_p comp_out_p start pfet_03v3 ad=1.38p pd=4.76u as=0.65p ps=3.3u w=1u l=0.28u
X527 start a_40628_3864# a_39428_3864# start pfet_03v3 ad=1.38p pd=4.76u as=0.65p ps=3.3u w=1u l=0.28u
X528 start a_56228_9464# a_55028_9464# start nfet_03v3 ad=0.66p pd=3.64u as=0.305p ps=2.22u w=0.5u l=0.28u
X529 start a_50628_54264# a_50508_54400# start pfet_03v3 ad=1.104p pd=4.36u as=0.52p ps=2.9u w=0.8u l=0.28u
X530 start start a_42908_19200# start pfet_03v3 ad=1.38p pd=4.76u as=0.65p ps=3.3u w=1u l=0.28u
X531 start a_45428_9464# a_44228_9464# start pfet_03v3 ad=1.38p pd=4.76u as=0.65p ps=3.3u w=1u l=0.28u
X532 start comp_out_p a_35494_36400# start nfet_03v3 ad=0.66p pd=3.64u as=0.305p ps=2.22u w=0.5u l=0.28u
X533 start a_19708_29600# dout[0] start nfet_03v3 ad=0.577p pd=3.52u as=0.2646p ps=2.1u w=0.42u l=0.28u
X534 start a_4508_6160# a_5708_6160# start pfet_03v3 ad=1.38p pd=4.76u as=0.65p ps=3.3u w=1u l=0.28u
X535 start start a_2908_41600# start pfet_03v3 ad=1.38p pd=4.76u as=0.65p ps=3.3u w=1u l=0.28u
X536 start a_49708_33600# a_51094_32400# start nfet_03v3 ad=0.66p pd=3.64u as=0.305p ps=2.22u w=0.5u l=0.28u
X537 start a_49028_15064# a_47828_15064# start pfet_03v3 ad=1.38p pd=4.76u as=0.65p ps=3.3u w=1u l=0.28u
X538 start a_10628_10824# a_9494_9600# start nfet_03v3 ad=0.66p pd=3.64u as=0.305p ps=2.22u w=0.5u l=0.28u
X539 start a_56108_12400# a_57308_12400# start nfet_03v3 ad=0.66p pd=3.64u as=0.305p ps=2.22u w=0.5u l=0.28u
X540 start a_24508_50400# a_25894_49200# start nfet_03v3 ad=0.66p pd=3.64u as=0.305p ps=2.22u w=0.5u l=0.28u
X541 start a_35308_29600# a_38108_50400# start nfet_03v3 ad=0.577p pd=3.52u as=0.2646p ps=2.1u w=0.42u l=0.28u
X542 start a_15028_10824# a_14908_10960# start nfet_03v3 ad=0.66p pd=3.64u as=0.305p ps=2.22u w=0.5u l=0.28u
X543 start dout[0] a_11308_29600# start pfet_03v3 ad=1.104p pd=4.36u as=0.52p ps=2.9u w=0.8u l=0.28u
X544 start a_3028_54264# a_3028_54264# start pfet_03v3 ad=1.104p pd=4.36u as=0.52p ps=2.9u w=0.8u l=0.28u
X545 start a_34108_33600# a_41308_33600# start pfet_03v3 ad=1.104p pd=4.36u as=0.52p ps=2.9u w=0.8u l=0.28u
X546 start a_2228_15624# a_2108_15760# start pfet_03v3 ad=1.38p pd=4.76u as=0.65p ps=3.3u w=1u l=0.28u
X547 start a_41828_9464# a_40628_9464# start nfet_03v3 ad=0.66p pd=3.64u as=0.305p ps=2.22u w=0.5u l=0.28u
X548 start a_19708_41600# dout[3] start pfet_03v3 ad=1.104p pd=4.36u as=0.52p ps=2.9u w=0.8u l=0.28u
X549 start a_23308_1360# a_24508_1360# start pfet_03v3 ad=1.38p pd=4.76u as=0.65p ps=3.3u w=1u l=0.28u
X550 start a_45308_12400# a_46508_12400# start pfet_03v3 ad=1.38p pd=4.76u as=0.65p ps=3.3u w=1u l=0.28u
X551 start start a_33308_24800# start pfet_03v3 ad=1.38p pd=4.76u as=0.65p ps=3.3u w=1u l=0.28u
X552 a_18508_1360# start a_19708_1360# start nfet_03v3 ad=0.305p pd=2.22u as=0.305p ps=2.22u w=0.5u l=0.28u
X553 start dac_in[4] dac_in[4] start pfet_03v3 ad=1.104p pd=4.36u as=0.52p ps=2.9u w=0.8u l=0.28u
X554 start a_43708_54400# dac_in[6] start pfet_03v3 ad=1.38p pd=4.76u as=0.65p ps=3.3u w=1u l=0.28u
X555 start a_3428_20424# a_3308_20560# start nfet_03v3 ad=0.66p pd=3.64u as=0.305p ps=2.22u w=0.5u l=0.28u
X556 start a_9308_10960# a_11708_10960# start pfet_03v3 ad=1.38p pd=4.76u as=0.65p ps=3.3u w=1u l=0.28u
X557 start comp_out_p a_51708_50400# start nfet_03v3 ad=0.577p pd=3.52u as=0.2646p ps=2.1u w=0.42u l=0.28u
X558 start a_51428_15064# a_50228_15064# start pfet_03v3 ad=1.38p pd=4.76u as=0.65p ps=3.3u w=1u l=0.28u
X559 start a_46628_3864# a_45428_3864# start nfet_03v3 ad=0.66p pd=3.64u as=0.305p ps=2.22u w=0.5u l=0.28u
X560 start a_38108_50400# a_39494_49200# start nfet_03v3 ad=0.66p pd=3.64u as=0.305p ps=2.22u w=0.5u l=0.28u
X561 start a_45428_3864# a_44228_3864# start pfet_03v3 ad=1.38p pd=4.76u as=0.65p ps=3.3u w=1u l=0.28u
X562 start a_9308_6160# a_8108_6160# start pfet_03v3 ad=0.6034p pd=3.64u as=0.2822p ps=2.18u w=0.42u l=2u
X563 a_4294_36400# comp_out_p comp_out_p start nfet_03v3 ad=0.305p pd=2.22u as=0.305p ps=2.22u w=0.5u l=0.28u
X564 start dout[1] a_11308_33600# start nfet_03v3 ad=0.577p pd=3.52u as=0.2646p ps=2.1u w=0.42u l=0.28u
X565 start a_50908_37600# dout[6] start pfet_03v3 ad=1.104p pd=4.36u as=0.52p ps=2.9u w=0.8u l=0.28u
X566 start a_48908_6800# a_50108_6800# start nfet_03v3 ad=0.66p pd=3.64u as=0.305p ps=2.22u w=0.5u l=0.28u
X567 start a_23428_6024# a_22108_6160# start pfet_03v3 ad=1.38p pd=4.76u as=0.65p ps=3.3u w=1u l=0.28u
X568 start dout[4] a_42508_29600# start nfet_03v3 ad=0.577p pd=3.52u as=0.2646p ps=2.1u w=0.42u l=0.28u
X569 start a_22108_10960# a_20908_10960# start nfet_03v3 ad=0.577p pd=3.52u as=0.2646p ps=2.1u w=0.42u l=2.4u
X570 start a_2908_46000# a_4108_46000# start nfet_03v3 ad=0.66p pd=3.64u as=0.305p ps=2.22u w=0.5u l=0.28u
X571 start a_46628_9464# a_45428_9464# start nfet_03v3 ad=0.66p pd=3.64u as=0.305p ps=2.22u w=0.5u l=0.28u
X572 start a_16628_54264# a_16508_54400# start pfet_03v3 ad=1.104p pd=4.36u as=0.52p ps=2.9u w=0.8u l=0.28u
X573 start a_50908_41600# dout[7] start nfet_03v3 ad=0.577p pd=3.52u as=0.2646p ps=2.1u w=0.42u l=0.28u
X574 start a_35828_9464# a_34628_9464# start pfet_03v3 ad=1.38p pd=4.76u as=0.65p ps=3.3u w=1u l=0.28u
X575 start a_17308_10960# a_18508_10960# start pfet_03v3 ad=1.38p pd=4.76u as=0.65p ps=3.3u w=1u l=0.28u
X576 start a_42908_12400# a_44108_12400# start nfet_03v3 ad=0.66p pd=3.64u as=0.305p ps=2.22u w=0.5u l=0.28u
X577 start a_44908_50400# a_46294_49200# start nfet_03v3 ad=0.66p pd=3.64u as=0.305p ps=2.22u w=0.5u l=0.28u
X578 start comp_done a_33308_19200# start nfet_03v3 ad=0.66p pd=3.64u as=0.305p ps=2.22u w=0.5u l=0.28u
X579 start a_48908_1200# a_50108_1200# start nfet_03v3 ad=0.66p pd=3.64u as=0.305p ps=2.22u w=0.5u l=0.28u
X580 start a_10108_37600# a_12508_37600# start pfet_03v3 ad=1.38p pd=4.76u as=0.65p ps=3.3u w=1u l=0.28u
X581 start a_5708_20560# a_4508_20560# start pfet_03v3 ad=0.6034p pd=3.64u as=0.2822p ps=2.18u w=0.42u l=2u
X582 start a_18508_15760# a_17308_15760# start nfet_03v3 ad=0.577p pd=3.52u as=0.2646p ps=2.1u w=0.42u l=2.4u
X583 start dout[1] a_9708_50400# start nfet_03v3 ad=0.577p pd=3.52u as=0.2646p ps=2.1u w=0.42u l=0.28u
X584 start dout[7] a_42508_41600# start pfet_03v3 ad=1.104p pd=4.36u as=0.52p ps=2.9u w=0.8u l=0.28u
X585 start a_5308_46000# a_6508_46000# start pfet_03v3 ad=1.38p pd=4.76u as=0.65p ps=3.3u w=1u l=0.28u
X586 start a_20908_46000# a_39708_24800# start nfet_03v3 ad=0.577p pd=3.52u as=0.2646p ps=2.1u w=0.42u l=0.28u
X587 start a_53708_6800# a_54908_6800# start nfet_03v3 ad=0.66p pd=3.64u as=0.305p ps=2.22u w=0.5u l=0.28u
X588 start a_33428_12264# a_33308_12400# start pfet_03v3 ad=1.38p pd=4.76u as=0.65p ps=3.3u w=1u l=0.28u
X589 a_51094_36400# a_48508_37600# a_50908_37600# start nfet_03v3 ad=0.305p pd=2.22u as=0.305p ps=2.22u w=0.5u l=0.28u
X590 start a_42908_6800# a_44108_6800# start pfet_03v3 ad=1.38p pd=4.76u as=0.65p ps=3.3u w=1u l=0.28u
X591 start dac_in[7] dac_in[7] start pfet_03v3 ad=1.104p pd=4.36u as=0.52p ps=2.9u w=0.8u l=0.28u
X592 start dout[1] a_18508_33600# start pfet_03v3 ad=1.104p pd=4.36u as=0.52p ps=2.9u w=0.8u l=0.28u
X593 start a_11828_1424# a_10694_0# start nfet_03v3 ad=0.66p pd=3.64u as=0.305p ps=2.22u w=0.5u l=0.28u
X594 start a_39308_1200# a_40508_1200# start nfet_03v3 ad=0.66p pd=3.64u as=0.305p ps=2.22u w=0.5u l=0.28u
X595 a_12694_40400# a_10108_41600# a_12508_41600# start nfet_03v3 ad=0.305p pd=2.22u as=0.305p ps=2.22u w=0.5u l=0.28u
X596 start a_4108_54400# dac_in[0] start pfet_03v3 ad=1.38p pd=4.76u as=0.65p ps=3.3u w=1u l=0.28u
X597 start comp_out_p a_17708_50400# start nfet_03v3 ad=0.577p pd=3.52u as=0.2646p ps=2.1u w=0.42u l=0.28u
X598 start a_35828_3864# a_34628_3864# start pfet_03v3 ad=1.38p pd=4.76u as=0.65p ps=3.3u w=1u l=0.28u
X599 start dout[4] a_49708_29600# start pfet_03v3 ad=1.104p pd=4.36u as=0.52p ps=2.9u w=0.8u l=0.28u
X600 start a_39308_6800# a_40508_6800# start nfet_03v3 ad=0.66p pd=3.64u as=0.305p ps=2.22u w=0.5u l=0.28u
X601 start a_59708_12400# a_60908_12400# start pfet_03v3 ad=1.38p pd=4.76u as=0.65p ps=3.3u w=1u l=0.28u
X602 start a_43708_33600# dout[5] start pfet_03v3 ad=1.104p pd=4.36u as=0.52p ps=2.9u w=0.8u l=0.28u
X603 start a_5708_15760# a_4508_15760# start pfet_03v3 ad=0.6034p pd=3.64u as=0.2822p ps=2.18u w=0.42u l=2u
X604 a_43894_36400# a_41308_37600# a_43708_37600# start nfet_03v3 ad=0.305p pd=2.22u as=0.305p ps=2.22u w=0.5u l=0.28u
X605 start a_2908_37600# a_10108_37600# start nfet_03v3 ad=0.577p pd=3.52u as=0.2646p ps=2.1u w=0.42u l=0.28u
X606 start dac_in[1] dac_in[1] start pfet_03v3 ad=1.104p pd=4.36u as=0.52p ps=2.9u w=0.8u l=0.28u
X607 start a_23308_54400# dac_in[3] start pfet_03v3 ad=1.38p pd=4.76u as=0.65p ps=3.3u w=1u l=0.28u
X608 a_19894_28400# a_17308_29600# a_19708_29600# start nfet_03v3 ad=0.305p pd=2.22u as=0.305p ps=2.22u w=0.5u l=0.28u
X609 a_5708_20560# a_2108_20560# a_8108_20560# start nfet_03v3 ad=0.305p pd=2.22u as=0.305p ps=2.22u w=0.5u l=0.28u
X610 start a_56228_15064# a_55028_15064# start pfet_03v3 ad=1.38p pd=4.76u as=0.65p ps=3.3u w=1u l=0.28u
X611 start a_42908_1200# a_44108_1200# start pfet_03v3 ad=1.38p pd=4.76u as=0.65p ps=3.3u w=1u l=0.28u
X612 start dout[4] start start pfet_03v3 ad=0.52p pd=2.9u as=0 ps=0 w=0.8u l=0.28u
X613 start a_47708_6800# a_48908_6800# start pfet_03v3 ad=1.38p pd=4.76u as=0.65p ps=3.3u w=1u l=0.28u
X614 start dout[5] a_49708_33600# start nfet_03v3 ad=0.577p pd=3.52u as=0.2646p ps=2.1u w=0.42u l=0.28u
X615 start a_3428_1424# start start pfet_03v3 ad=0.65p pd=3.3u as=0 ps=0 w=1u l=0.28u
X616 a_18508_1360# a_17308_1360# a_19708_1360# start pfet_03v3 ad=0.65p pd=3.3u as=0.65p ps=3.3u w=1u l=0.28u
X617 a_53094_53200# a_50508_54400# dac_in[7] start nfet_03v3 ad=0.305p pd=2.22u as=0.305p ps=2.22u w=0.5u l=0.28u
X618 start a_15028_15624# a_14908_15760# start pfet_03v3 ad=1.38p pd=4.76u as=0.65p ps=3.3u w=1u l=0.28u
X619 start a_3028_54264# a_3028_54264# start nfet_03v3 ad=0.577p pd=3.52u as=0.2646p ps=2.1u w=0.42u l=0.28u
X620 start a_52508_12400# a_53708_12400# start pfet_03v3 ad=1.38p pd=4.76u as=0.65p ps=3.3u w=1u l=0.28u
X621 start a_8908_46000# a_10108_46000# start nfet_03v3 ad=0.66p pd=3.64u as=0.305p ps=2.22u w=0.5u l=0.28u
X622 start a_59828_15064# a_58628_15064# start nfet_03v3 ad=0.66p pd=3.64u as=0.305p ps=2.22u w=0.5u l=0.28u
X623 start start a_4108_54400# start nfet_03v3 ad=0.577p pd=3.52u as=0.2646p ps=2.1u w=0.42u l=0.28u
X624 start a_17308_41600# a_19708_41600# start pfet_03v3 ad=1.38p pd=4.76u as=0.65p ps=3.3u w=1u l=0.28u
X625 start a_44108_6800# a_45308_6800# start nfet_03v3 ad=0.66p pd=3.64u as=0.305p ps=2.22u w=0.5u l=0.28u
X626 start a_7708_46000# a_8908_46000# start nfet_03v3 ad=0.66p pd=3.64u as=0.305p ps=2.22u w=0.5u l=0.28u
X627 start a_17308_6160# a_18508_6160# start pfet_03v3 ad=1.38p pd=4.76u as=0.65p ps=3.3u w=1u l=0.28u
X628 start a_33308_6800# a_34508_6800# start pfet_03v3 ad=1.38p pd=4.76u as=0.65p ps=3.3u w=1u l=0.28u
X629 start a_9308_20560# a_8108_20560# start pfet_03v3 ad=0.6034p pd=3.64u as=0.2822p ps=2.18u w=0.42u l=2u
X630 start dout[5] a_36908_50400# start pfet_03v3 ad=1.104p pd=4.36u as=0.52p ps=2.9u w=0.8u l=0.28u
X631 start a_47708_12400# a_48908_12400# start nfet_03v3 ad=0.66p pd=3.64u as=0.305p ps=2.22u w=0.5u l=0.28u
X632 start a_11308_46000# a_12508_46000# start pfet_03v3 ad=1.38p pd=4.76u as=0.65p ps=3.3u w=1u l=0.28u
X633 start start a_35308_29600# start pfet_03v3 ad=1.38p pd=4.76u as=0.65p ps=3.3u w=1u l=0.28u
X634 start a_33308_24800# sample_en start nfet_03v3 ad=0.66p pd=3.64u as=0.305p ps=2.22u w=0.5u l=0.28u
X635 start a_47708_1200# a_48908_1200# start pfet_03v3 ad=1.38p pd=4.76u as=0.65p ps=3.3u w=1u l=0.28u
X636 a_12294_53200# a_9708_54400# dac_in[1] start nfet_03v3 ad=0.305p pd=2.22u as=0.305p ps=2.22u w=0.5u l=0.28u
X637 start a_23428_54264# a_23308_54400# start nfet_03v3 ad=0.577p pd=3.52u as=0.2646p ps=2.1u w=0.42u l=0.28u
X638 start comp_out_p a_17308_37600# start pfet_03v3 ad=1.104p pd=4.36u as=0.52p ps=2.9u w=0.8u l=0.28u
X639 start start start start pfet_03v3 ad=0.2822p pd=2.18u as=0 ps=0 w=0.42u l=2u
X640 start start start start nfet_03v3 ad=0.305p pd=2.22u as=0 ps=0 w=0.5u l=0.28u
X641 start a_58508_6800# a_59708_6800# start pfet_03v3 ad=1.38p pd=4.76u as=0.65p ps=3.3u w=1u l=0.28u
X642 start a_36908_12400# a_38108_12400# start pfet_03v3 ad=1.38p pd=4.76u as=0.65p ps=3.3u w=1u l=0.28u
X643 start a_40908_24800# rst_latch start pfet_03v3 ad=1.38p pd=4.76u as=0.65p ps=3.3u w=1u l=0.28u
X644 start a_22108_10960# a_20908_10960# start pfet_03v3 ad=0.6034p pd=3.64u as=0.2822p ps=2.18u w=0.42u l=2u
X645 start a_50108_12400# a_51308_12400# start nfet_03v3 ad=0.66p pd=3.64u as=0.305p ps=2.22u w=0.5u l=0.28u
X646 start dout[7] a_50508_50400# start pfet_03v3 ad=1.104p pd=4.36u as=0.52p ps=2.9u w=0.8u l=0.28u
X647 start a_35308_29600# a_35494_32400# start nfet_03v3 ad=0.66p pd=3.64u as=0.305p ps=2.22u w=0.5u l=0.28u
X648 start a_7708_41600# a_17308_41600# start nfet_03v3 ad=0.577p pd=3.52u as=0.2646p ps=2.1u w=0.42u l=0.28u
X649 start start start start nfet_03v3 ad=0.305p pd=2.22u as=0 ps=0 w=0.5u l=0.28u
X650 start a_33308_1200# a_34508_1200# start pfet_03v3 ad=1.38p pd=4.76u as=0.65p ps=3.3u w=1u l=0.28u
X651 start a_59708_1200# a_60908_1200# start nfet_03v3 ad=0.66p pd=3.64u as=0.305p ps=2.22u w=0.5u l=0.28u
X652 start a_42508_37600# a_43708_37600# start pfet_03v3 ad=1.38p pd=4.76u as=0.65p ps=3.3u w=1u l=0.28u
X653 start a_9308_15760# a_8108_15760# start pfet_03v3 ad=0.6034p pd=3.64u as=0.2822p ps=2.18u w=0.42u l=2u
X654 start a_38108_6800# a_39308_6800# start pfet_03v3 ad=1.38p pd=4.76u as=0.65p ps=3.3u w=1u l=0.28u
X655 a_19094_53200# a_16508_54400# dac_in[2] start nfet_03v3 ad=0.305p pd=2.22u as=0.305p ps=2.22u w=0.5u l=0.28u
X656 a_35894_23600# sample_en a_35708_24800# start nfet_03v3 ad=0.305p pd=2.22u as=0.305p ps=2.22u w=0.5u l=0.28u
X657 start a_43028_9464# a_41828_9464# start pfet_03v3 ad=1.38p pd=4.76u as=0.65p ps=3.3u w=1u l=0.28u
X658 start a_39308_12400# a_40508_12400# start pfet_03v3 ad=1.38p pd=4.76u as=0.65p ps=3.3u w=1u l=0.28u
X659 start a_46628_15064# a_45428_15064# start nfet_03v3 ad=0.66p pd=3.64u as=0.305p ps=2.22u w=0.5u l=0.28u
X660 start a_3428_6024# a_3308_6160# start pfet_03v3 ad=1.38p pd=4.76u as=0.65p ps=3.3u w=1u l=0.28u
X661 start comp_out_p comp_out_p start pfet_03v3 ad=1.38p pd=4.76u as=0.65p ps=3.3u w=1u l=0.28u
X662 start comp_out_p a_48508_37600# start nfet_03v3 ad=0.577p pd=3.52u as=0.2646p ps=2.1u w=0.42u l=0.28u
X663 start a_58508_1200# a_59708_1200# start pfet_03v3 ad=1.38p pd=4.76u as=0.65p ps=3.3u w=1u l=0.28u
X664 start a_50108_1200# a_51308_1200# start nfet_03v3 ad=0.66p pd=3.64u as=0.305p ps=2.22u w=0.5u l=0.28u
X665 start start a_34108_29600# start nfet_03v3 ad=0.66p pd=3.64u as=0.305p ps=2.22u w=0.5u l=0.28u
X666 start a_12508_37600# dout[2] start nfet_03v3 ad=0.577p pd=3.52u as=0.2646p ps=2.1u w=0.42u l=0.28u
X667 start a_34508_6800# a_35708_6800# start nfet_03v3 ad=0.66p pd=3.64u as=0.305p ps=2.22u w=0.5u l=0.28u
X668 start a_42508_41600# a_43894_40400# start nfet_03v3 ad=0.66p pd=3.64u as=0.305p ps=2.22u w=0.5u l=0.28u
X669 start a_4508_10960# a_5708_10960# start nfet_03v3 ad=0.66p pd=3.64u as=0.305p ps=2.22u w=0.5u l=0.28u
X670 start a_30228_54264# a_30228_54264# start pfet_03v3 ad=1.104p pd=4.36u as=0.52p ps=2.9u w=0.8u l=0.28u
X671 start a_43708_50400# a_43828_54264# start pfet_03v3 ad=1.38p pd=4.76u as=0.65p ps=3.3u w=1u l=0.28u
X672 start comp_out_p comp_out_p start nfet_03v3 ad=0.66p pd=3.64u as=0.305p ps=2.22u w=0.5u l=0.28u
X673 a_3308_10960# a_2108_10960# a_4508_10960# start pfet_03v3 ad=0.65p pd=3.3u as=0.65p ps=3.3u w=1u l=0.28u
X674 a_32694_53200# start dac_in[4] start nfet_03v3 ad=0.305p pd=2.22u as=0.305p ps=2.22u w=0.5u l=0.28u
X675 start a_43828_54264# a_43708_54400# start nfet_03v3 ad=0.577p pd=3.52u as=0.2646p ps=2.1u w=0.42u l=0.28u
X676 a_18508_15760# a_14908_15760# a_20908_15760# start nfet_03v3 ad=0.305p pd=2.22u as=0.305p ps=2.22u w=0.5u l=0.28u
X677 start dac_in[2] dac_in[2] start nfet_03v3 ad=0.577p pd=3.52u as=0.2646p ps=2.1u w=0.42u l=0.28u
X678 a_4294_32400# comp_out_p comp_out_p start nfet_03v3 ad=0.305p pd=2.22u as=0.305p ps=2.22u w=0.5u l=0.28u
X679 start start a_40908_24800# start nfet_03v3 ad=0.577p pd=3.52u as=0.2646p ps=2.1u w=0.42u l=0.28u
X680 start a_20908_1360# a_19708_1360# start pfet_03v3 ad=0.6034p pd=3.64u as=0.2822p ps=2.18u w=0.42u l=2u
X681 start a_40508_1200# a_41708_1200# start nfet_03v3 ad=0.66p pd=3.64u as=0.305p ps=2.22u w=0.5u l=0.28u
X682 start a_50908_33600# dout[5] start pfet_03v3 ad=1.104p pd=4.36u as=0.52p ps=2.9u w=0.8u l=0.28u
X683 start a_13708_46000# a_14908_46000# start nfet_03v3 ad=0.66p pd=3.64u as=0.305p ps=2.22u w=0.5u l=0.28u
X684 start start a_34108_41600# start pfet_03v3 ad=1.38p pd=4.76u as=0.65p ps=3.3u w=1u l=0.28u
X685 start a_4508_15760# a_5708_15760# start nfet_03v3 ad=0.66p pd=3.64u as=0.305p ps=2.22u w=0.5u l=0.28u
X686 start a_38108_1200# a_39308_1200# start pfet_03v3 ad=1.38p pd=4.76u as=0.65p ps=3.3u w=1u l=0.28u
X687 start a_57308_12400# a_58508_12400# start pfet_03v3 ad=1.38p pd=4.76u as=0.65p ps=3.3u w=1u l=0.28u
X688 start a_44228_3864# a_43028_3864# start nfet_03v3 ad=0.66p pd=3.64u as=0.305p ps=2.22u w=0.5u l=0.28u
X689 start a_43028_3864# a_41828_3864# start pfet_03v3 ad=1.38p pd=4.76u as=0.65p ps=3.3u w=1u l=0.28u
X690 start a_22108_6160# a_24508_6160# start nfet_03v3 ad=0.66p pd=3.64u as=0.305p ps=2.22u w=0.5u l=0.28u
X691 start a_4108_41600# a_7708_41600# start pfet_03v3 ad=1.38p pd=4.76u as=0.65p ps=3.3u w=1u l=0.28u
X692 a_5708_6160# a_2228_6024# a_8108_6160# start pfet_03v3 ad=0.65p pd=3.3u as=0.65p ps=3.3u w=1u l=0.28u
X693 start a_53828_9464# a_52628_9464# start pfet_03v3 ad=1.38p pd=4.76u as=0.65p ps=3.3u w=1u l=0.28u
X694 start dout[4] start start nfet_03v3 ad=0.2646p pd=2.1u as=0 ps=0 w=0.42u l=0.28u
X695 a_18508_6160# a_15028_6024# a_20908_6160# start pfet_03v3 ad=0.65p pd=3.3u as=0.65p ps=3.3u w=1u l=0.28u
X696 start a_20908_15760# a_22108_15760# start pfet_03v3 ad=1.38p pd=4.76u as=0.65p ps=3.3u w=1u l=0.28u
X697 start dout[2] a_16508_50400# start pfet_03v3 ad=1.104p pd=4.36u as=0.52p ps=2.9u w=0.8u l=0.28u
X698 start a_48508_29600# a_50908_29600# start pfet_03v3 ad=1.38p pd=4.76u as=0.65p ps=3.3u w=1u l=0.28u
X699 start a_9308_10960# a_8108_10960# start nfet_03v3 ad=0.577p pd=3.52u as=0.2646p ps=2.1u w=0.42u l=2.4u
X700 start a_16108_46000# a_17308_46000# start pfet_03v3 ad=1.38p pd=4.76u as=0.65p ps=3.3u w=1u l=0.28u
X701 a_39494_53200# a_36908_54400# dac_in[5] start nfet_03v3 ad=0.305p pd=2.22u as=0.305p ps=2.22u w=0.5u l=0.28u
X702 start dac_in[3] dac_in[3] start nfet_03v3 ad=0.577p pd=3.52u as=0.2646p ps=2.1u w=0.42u l=0.28u
X703 start a_23428_10824# a_22294_9600# start nfet_03v3 ad=0.66p pd=3.64u as=0.305p ps=2.22u w=0.5u l=0.28u
X704 start a_44228_9464# a_43028_9464# start nfet_03v3 ad=0.66p pd=3.64u as=0.305p ps=2.22u w=0.5u l=0.28u
X705 start comp_out_p comp_out_p start pfet_03v3 ad=1.38p pd=4.76u as=0.65p ps=3.3u w=1u l=0.28u
X706 start a_10108_33600# a_12508_33600# start pfet_03v3 ad=1.38p pd=4.76u as=0.65p ps=3.3u w=1u l=0.28u
X707 start a_24508_1360# a_26908_1360# start pfet_03v3 ad=1.38p pd=4.76u as=0.65p ps=3.3u w=1u l=0.28u
X708 start a_33428_9464# a_33308_9600# start pfet_03v3 ad=1.38p pd=4.76u as=0.65p ps=3.3u w=1u l=0.28u
X709 a_35494_36400# comp_out_p comp_out_p start nfet_03v3 ad=0.305p pd=2.22u as=0.305p ps=2.22u w=0.5u l=0.28u
X710 start a_18508_29600# a_19894_28400# start nfet_03v3 ad=0.66p pd=3.64u as=0.305p ps=2.22u w=0.5u l=0.28u
X711 a_51094_32400# a_48508_33600# a_50908_33600# start nfet_03v3 ad=0.305p pd=2.22u as=0.305p ps=2.22u w=0.5u l=0.28u
X712 start a_50628_54264# a_50628_54264# start pfet_03v3 ad=1.104p pd=4.36u as=0.52p ps=2.9u w=0.8u l=0.28u
X713 start a_33308_24800# a_35708_24800# start pfet_03v3 ad=1.38p pd=4.76u as=0.65p ps=3.3u w=1u l=0.28u
X714 start a_11828_1424# start start pfet_03v3 ad=0.65p pd=3.3u as=0 ps=0 w=1u l=0.28u
X715 start a_54908_12400# a_56108_12400# start nfet_03v3 ad=0.66p pd=3.64u as=0.305p ps=2.22u w=0.5u l=0.28u
X716 start a_49028_3864# sample_en start nfet_03v3 ad=0.66p pd=3.64u as=0.305p ps=2.22u w=0.5u l=0.28u
X717 start dout[5] a_36908_50400# start nfet_03v3 ad=0.577p pd=3.52u as=0.2646p ps=2.1u w=0.42u l=0.28u
X718 start dac_in[5] dac_in[5] start nfet_03v3 ad=0.577p pd=3.52u as=0.2646p ps=2.1u w=0.42u l=0.28u
X719 start a_41308_29600# a_43708_29600# start pfet_03v3 ad=1.38p pd=4.76u as=0.65p ps=3.3u w=1u l=0.28u
X720 start a_53828_3864# a_52628_3864# start pfet_03v3 ad=1.38p pd=4.76u as=0.65p ps=3.3u w=1u l=0.28u
X721 start a_2908_29600# a_10108_29600# start pfet_03v3 ad=1.104p pd=4.36u as=0.52p ps=2.9u w=0.8u l=0.28u
X722 start a_58628_9464# a_57428_9464# start pfet_03v3 ad=1.38p pd=4.76u as=0.65p ps=3.3u w=1u l=0.28u
X723 start a_61028_15064# a_59828_15064# start nfet_03v3 ad=0.66p pd=3.64u as=0.305p ps=2.22u w=0.5u l=0.28u
X724 start a_4108_50400# a_3028_54264# start pfet_03v3 ad=1.38p pd=4.76u as=0.65p ps=3.3u w=1u l=0.28u
X725 start comp_out_p a_4294_40400# start nfet_03v3 ad=0.66p pd=3.64u as=0.305p ps=2.22u w=0.5u l=0.28u
X726 start a_18508_41600# a_19708_41600# start pfet_03v3 ad=1.38p pd=4.76u as=0.65p ps=3.3u w=1u l=0.28u
X727 start a_44108_12400# a_45308_12400# start pfet_03v3 ad=1.38p pd=4.76u as=0.65p ps=3.3u w=1u l=0.28u
X728 start start a_44908_54400# start pfet_03v3 ad=1.104p pd=4.36u as=0.52p ps=2.9u w=0.8u l=0.28u
X729 start a_11308_29600# a_12694_28400# start nfet_03v3 ad=0.66p pd=3.64u as=0.305p ps=2.22u w=0.5u l=0.28u
X730 start a_35308_29600# a_35308_29600# start nfet_03v3 ad=0.66p pd=3.64u as=0.305p ps=2.22u w=0.5u l=0.28u
X731 start a_2228_20424# a_2108_20560# start nfet_03v3 ad=0.66p pd=3.64u as=0.305p ps=2.22u w=0.5u l=0.28u
X732 start a_50228_15064# a_49028_15064# start pfet_03v3 ad=1.38p pd=4.76u as=0.65p ps=3.3u w=1u l=0.28u
X733 start a_10628_10824# a_9308_10960# start pfet_03v3 ad=1.38p pd=4.76u as=0.65p ps=3.3u w=1u l=0.28u
X734 start dout[7] a_50508_50400# start nfet_03v3 ad=0.577p pd=3.52u as=0.2646p ps=2.1u w=0.42u l=0.28u
X735 a_43894_32400# a_41308_33600# a_43708_33600# start nfet_03v3 ad=0.305p pd=2.22u as=0.305p ps=2.22u w=0.5u l=0.28u
X736 start start start start nfet_03v3 ad=0.2646p pd=2.1u as=0 ps=0 w=0.42u l=2.4u
X737 start a_34628_3864# a_33428_3864# start nfet_03v3 ad=0.66p pd=3.64u as=0.305p ps=2.22u w=0.5u l=0.28u
X738 start a_49028_9464# a_47828_9464# start nfet_03v3 ad=0.66p pd=3.64u as=0.305p ps=2.22u w=0.5u l=0.28u
X739 start a_41708_1200# a_42908_1200# start nfet_03v3 ad=0.66p pd=3.64u as=0.305p ps=2.22u w=0.5u l=0.28u
X740 start a_33428_3864# a_33308_4000# start pfet_03v3 ad=1.38p pd=4.76u as=0.65p ps=3.3u w=1u l=0.28u
X741 start a_38228_9464# a_37028_9464# start pfet_03v3 ad=1.38p pd=4.76u as=0.65p ps=3.3u w=1u l=0.28u
X742 start a_23308_50400# a_23428_54264# start pfet_03v3 ad=1.38p pd=4.76u as=0.65p ps=3.3u w=1u l=0.28u
X743 start start a_2908_37600# start nfet_03v3 ad=0.66p pd=3.64u as=0.305p ps=2.22u w=0.5u l=0.28u
X744 start a_2908_33600# a_10108_33600# start nfet_03v3 ad=0.577p pd=3.52u as=0.2646p ps=2.1u w=0.42u l=0.28u
X745 start a_9828_54264# a_9828_54264# start pfet_03v3 ad=1.104p pd=4.36u as=0.52p ps=2.9u w=0.8u l=0.28u
X746 start a_49708_37600# a_50908_37600# start pfet_03v3 ad=1.38p pd=4.76u as=0.65p ps=3.3u w=1u l=0.28u
X747 start a_8108_10960# a_9308_10960# start pfet_03v3 ad=1.38p pd=4.76u as=0.65p ps=3.3u w=1u l=0.28u
X748 start a_9308_15760# a_11708_15760# start nfet_03v3 ad=0.66p pd=3.64u as=0.305p ps=2.22u w=0.5u l=0.28u
X749 start dac_in[6] dac_in[6] start nfet_03v3 ad=0.577p pd=3.52u as=0.2646p ps=2.1u w=0.42u l=0.28u
X750 start a_53828_15064# a_52628_15064# start nfet_03v3 ad=0.66p pd=3.64u as=0.305p ps=2.22u w=0.5u l=0.28u
X751 start a_59828_3864# a_58628_3864# start nfet_03v3 ad=0.66p pd=3.64u as=0.305p ps=2.22u w=0.5u l=0.28u
X752 start start a_33308_1200# start nfet_03v3 ad=0.66p pd=3.64u as=0.305p ps=2.22u w=0.5u l=0.28u
X753 start a_11308_41600# a_12508_41600# start pfet_03v3 ad=1.38p pd=4.76u as=0.65p ps=3.3u w=1u l=0.28u
X754 start a_35308_41600# a_38908_41600# start pfet_03v3 ad=1.38p pd=4.76u as=0.65p ps=3.3u w=1u l=0.28u
X755 start a_58628_3864# a_57428_3864# start pfet_03v3 ad=1.38p pd=4.76u as=0.65p ps=3.3u w=1u l=0.28u
X756 start a_34108_29600# a_41308_29600# start nfet_03v3 ad=0.577p pd=3.52u as=0.2646p ps=2.1u w=0.42u l=0.28u
X757 start comp_done a_2908_46000# start nfet_03v3 ad=0.66p pd=3.64u as=0.305p ps=2.22u w=0.5u l=0.28u
X758 start a_19708_37600# dout[2] start nfet_03v3 ad=0.577p pd=3.52u as=0.2646p ps=2.1u w=0.42u l=0.28u
X759 start a_34628_9464# a_33428_9464# start nfet_03v3 ad=0.66p pd=3.64u as=0.305p ps=2.22u w=0.5u l=0.28u
X760 start a_49708_41600# a_51094_40400# start nfet_03v3 ad=0.66p pd=3.64u as=0.305p ps=2.22u w=0.5u l=0.28u
X761 start start a_17308_1360# start pfet_03v3 ad=1.38p pd=4.76u as=0.65p ps=3.3u w=1u l=0.28u
X762 start a_51308_6800# a_52508_6800# start pfet_03v3 ad=1.38p pd=4.76u as=0.65p ps=3.3u w=1u l=0.28u
X763 a_16108_10960# a_14908_10960# a_17308_10960# start pfet_03v3 ad=0.65p pd=3.3u as=0.65p ps=3.3u w=1u l=0.28u
X764 a_46294_49200# a_43708_50400# a_43828_54264# start nfet_03v3 ad=0.305p pd=2.22u as=0.305p ps=2.22u w=0.5u l=0.28u
X765 start a_41708_12400# a_42908_12400# start nfet_03v3 ad=0.66p pd=3.64u as=0.305p ps=2.22u w=0.5u l=0.28u
X766 start a_30228_54264# a_30228_54264# start nfet_03v3 ad=0.577p pd=3.52u as=0.2646p ps=2.1u w=0.42u l=0.28u
X767 start a_51308_1200# a_52508_1200# start nfet_03v3 ad=0.66p pd=3.64u as=0.305p ps=2.22u w=0.5u l=0.28u
X768 start a_39428_3864# a_38228_3864# start nfet_03v3 ad=0.66p pd=3.64u as=0.305p ps=2.22u w=0.5u l=0.28u
X769 start dout[2] a_11308_37600# start pfet_03v3 ad=1.104p pd=4.36u as=0.52p ps=2.9u w=0.8u l=0.28u
X770 start a_38228_3864# a_37028_3864# start pfet_03v3 ad=1.38p pd=4.76u as=0.65p ps=3.3u w=1u l=0.28u
X771 start a_18508_6160# a_17308_6160# start nfet_03v3 ad=0.577p pd=3.52u as=0.2646p ps=2.1u w=0.42u l=2.4u
X772 start a_17308_15760# a_18508_15760# start nfet_03v3 ad=0.66p pd=3.64u as=0.305p ps=2.22u w=0.5u l=0.28u
X773 start a_59828_9464# a_58628_9464# start nfet_03v3 ad=0.66p pd=3.64u as=0.305p ps=2.22u w=0.5u l=0.28u
X774 start a_4108_46000# a_5308_46000# start pfet_03v3 ad=1.38p pd=4.76u as=0.65p ps=3.3u w=1u l=0.28u
X775 start a_34108_41600# a_41308_41600# start pfet_03v3 ad=1.104p pd=4.36u as=0.52p ps=2.9u w=0.8u l=0.28u
X776 start a_41708_6800# a_42908_6800# start nfet_03v3 ad=0.66p pd=3.64u as=0.305p ps=2.22u w=0.5u l=0.28u
X777 start a_9308_6160# a_11708_6160# start pfet_03v3 ad=1.38p pd=4.76u as=0.65p ps=3.3u w=1u l=0.28u
X778 start comp_out_p a_17308_33600# start pfet_03v3 ad=1.104p pd=4.36u as=0.52p ps=2.9u w=0.8u l=0.28u
X779 start a_16228_6024# a_16108_6160# start pfet_03v3 ad=1.38p pd=4.76u as=0.65p ps=3.3u w=1u l=0.28u
X780 start a_51708_54400# dac_in[7] start pfet_03v3 ad=1.38p pd=4.76u as=0.65p ps=3.3u w=1u l=0.28u
X781 start dout[3] a_11308_41600# start nfet_03v3 ad=0.577p pd=3.52u as=0.2646p ps=2.1u w=0.42u l=0.28u
X782 start a_17308_10960# a_18508_10960# start nfet_03v3 ad=0.66p pd=3.64u as=0.305p ps=2.22u w=0.5u l=0.28u
X783 start a_34508_12400# a_35708_12400# start nfet_03v3 ad=0.66p pd=3.64u as=0.305p ps=2.22u w=0.5u l=0.28u
X784 start a_2908_54400# dac_in[0] start pfet_03v3 ad=1.38p pd=4.76u as=0.65p ps=3.3u w=1u l=0.28u
X785 start dout[2] a_16508_50400# start nfet_03v3 ad=0.577p pd=3.52u as=0.2646p ps=2.1u w=0.42u l=0.28u
X786 start a_51308_1200# a_52508_1200# start pfet_03v3 ad=1.38p pd=4.76u as=0.65p ps=3.3u w=1u l=0.28u
X787 start a_39428_9464# a_38228_9464# start nfet_03v3 ad=0.66p pd=3.64u as=0.305p ps=2.22u w=0.5u l=0.28u
X788 start a_18508_15760# a_17308_15760# start pfet_03v3 ad=0.6034p pd=3.64u as=0.2822p ps=2.18u w=0.42u l=2u
X789 start a_56108_6800# a_57308_6800# start pfet_03v3 ad=1.38p pd=4.76u as=0.65p ps=3.3u w=1u l=0.28u
X790 start a_35308_29600# a_48508_29600# start pfet_03v3 ad=1.104p pd=4.36u as=0.52p ps=2.9u w=0.8u l=0.28u
X791 start a_12508_29600# dout[0] start pfet_03v3 ad=1.104p pd=4.36u as=0.52p ps=2.9u w=0.8u l=0.28u
X792 start a_42508_33600# a_43708_33600# start pfet_03v3 ad=1.38p pd=4.76u as=0.65p ps=3.3u w=1u l=0.28u
X793 start a_61028_9464# a_59828_9464# start pfet_03v3 ad=1.38p pd=4.76u as=0.65p ps=3.3u w=1u l=0.28u
X794 start dout[6] a_42508_37600# start nfet_03v3 ad=0.577p pd=3.52u as=0.2646p ps=2.1u w=0.42u l=0.28u
X795 start start a_24508_54400# start pfet_03v3 ad=1.104p pd=4.36u as=0.52p ps=2.9u w=0.8u l=0.28u
X796 start a_10908_54400# dac_in[1] start pfet_03v3 ad=1.38p pd=4.76u as=0.65p ps=3.3u w=1u l=0.28u
X797 start dout[0] a_18508_29600# start nfet_03v3 ad=0.577p pd=3.52u as=0.2646p ps=2.1u w=0.42u l=0.28u
X798 start a_5708_20560# a_4508_20560# start nfet_03v3 ad=0.577p pd=3.52u as=0.2646p ps=2.1u w=0.42u l=2.4u
X799 start a_55028_15064# a_53828_15064# start pfet_03v3 ad=1.38p pd=4.76u as=0.65p ps=3.3u w=1u l=0.28u
X800 start a_50628_54264# a_50628_54264# start nfet_03v3 ad=0.577p pd=3.52u as=0.2646p ps=2.1u w=0.42u l=0.28u
X801 start comp_out_p a_48508_33600# start nfet_03v3 ad=0.577p pd=3.52u as=0.2646p ps=2.1u w=0.42u l=0.28u
X802 start a_52508_6800# a_53708_6800# start nfet_03v3 ad=0.66p pd=3.64u as=0.305p ps=2.22u w=0.5u l=0.28u
X803 start a_35708_6800# a_36908_6800# start pfet_03v3 ad=1.38p pd=4.76u as=0.65p ps=3.3u w=1u l=0.28u
X804 a_3308_6160# a_2228_6024# a_4508_6160# start nfet_03v3 ad=0.305p pd=2.22u as=0.305p ps=2.22u w=0.5u l=0.28u
X805 start a_12508_33600# dout[1] start nfet_03v3 ad=0.577p pd=3.52u as=0.2646p ps=2.1u w=0.42u l=0.28u
X806 start a_4108_50400# a_5494_49200# start nfet_03v3 ad=0.66p pd=3.64u as=0.305p ps=2.22u w=0.5u l=0.28u
X807 start a_51308_12400# a_52508_12400# start pfet_03v3 ad=1.38p pd=4.76u as=0.65p ps=3.3u w=1u l=0.28u
X808 start a_58628_15064# a_57428_15064# start nfet_03v3 ad=0.66p pd=3.64u as=0.305p ps=2.22u w=0.5u l=0.28u
X809 start a_56108_1200# a_57308_1200# start pfet_03v3 ad=1.38p pd=4.76u as=0.65p ps=3.3u w=1u l=0.28u
X810 start a_3028_54264# a_2908_54400# start nfet_03v3 ad=0.577p pd=3.52u as=0.2646p ps=2.1u w=0.42u l=0.28u
X811 start dout[3] a_18508_41600# start pfet_03v3 ad=1.104p pd=4.36u as=0.52p ps=2.9u w=0.8u l=0.28u
X812 start a_33428_6664# a_33308_6800# start nfet_03v3 ad=0.66p pd=3.64u as=0.305p ps=2.22u w=0.5u l=0.28u
X813 start a_43708_29600# dout[4] start nfet_03v3 ad=0.577p pd=3.52u as=0.2646p ps=2.1u w=0.42u l=0.28u
X814 start a_61028_3864# a_59828_3864# start pfet_03v3 ad=1.38p pd=4.76u as=0.65p ps=3.3u w=1u l=0.28u
X815 start a_3428_10824# a_3308_10960# start nfet_03v3 ad=0.66p pd=3.64u as=0.305p ps=2.22u w=0.5u l=0.28u
X816 start a_47828_15064# a_46628_15064# start pfet_03v3 ad=1.38p pd=4.76u as=0.65p ps=3.3u w=1u l=0.28u
X817 start a_9828_54264# a_9828_54264# start nfet_03v3 ad=0.577p pd=3.52u as=0.2646p ps=2.1u w=0.42u l=0.28u
X818 a_25894_49200# a_23308_50400# a_23428_54264# start nfet_03v3 ad=0.305p pd=2.22u as=0.305p ps=2.22u w=0.5u l=0.28u
X819 start a_10108_46000# a_11308_46000# start pfet_03v3 ad=1.38p pd=4.76u as=0.65p ps=3.3u w=1u l=0.28u
X820 start dout[6] a_49708_37600# start pfet_03v3 ad=1.104p pd=4.36u as=0.52p ps=2.9u w=0.8u l=0.28u
X821 start comp_out_p a_35308_29600# start pfet_03v3 ad=1.38p pd=4.76u as=0.65p ps=3.3u w=1u l=0.28u
X822 start a_35708_1200# a_36908_1200# start pfet_03v3 ad=1.38p pd=4.76u as=0.65p ps=3.3u w=1u l=0.28u
X823 start start a_10908_54400# start nfet_03v3 ad=0.577p pd=3.52u as=0.2646p ps=2.1u w=0.42u l=0.28u
X824 start start start start nfet_03v3 ad=0.2646p pd=2.1u as=0 ps=0 w=0.42u l=0.28u
X825 start a_42908_1200# a_44108_1200# start nfet_03v3 ad=0.66p pd=3.64u as=0.305p ps=2.22u w=0.5u l=0.28u
X826 a_9494_4800# a_8108_6160# a_9308_6160# start nfet_03v3 ad=0.305p pd=2.22u as=0.305p ps=2.22u w=0.5u l=0.28u
X827 start a_57308_6800# a_58508_6800# start nfet_03v3 ad=0.66p pd=3.64u as=0.305p ps=2.22u w=0.5u l=0.28u
X828 start a_43708_41600# dout[7] start pfet_03v3 ad=1.104p pd=4.36u as=0.52p ps=2.9u w=0.8u l=0.28u
X829 a_22294_4800# a_20908_6160# a_22108_6160# start nfet_03v3 ad=0.305p pd=2.22u as=0.305p ps=2.22u w=0.5u l=0.28u
X830 start a_46508_6800# a_47708_6800# start pfet_03v3 ad=1.38p pd=4.76u as=0.65p ps=3.3u w=1u l=0.28u
X831 start a_35708_12400# a_36908_12400# start pfet_03v3 ad=1.38p pd=4.76u as=0.65p ps=3.3u w=1u l=0.28u
X832 start a_51428_9464# a_50228_9464# start pfet_03v3 ad=1.38p pd=4.76u as=0.65p ps=3.3u w=1u l=0.28u
X833 start start dac_in[4] start pfet_03v3 ad=1.38p pd=4.76u as=0.65p ps=3.3u w=1u l=0.28u
X834 start a_19708_1360# a_20908_1360# start nfet_03v3 ad=0.66p pd=3.64u as=0.305p ps=2.22u w=0.5u l=0.28u
X835 start a_22108_10960# a_24508_10960# start pfet_03v3 ad=1.38p pd=4.76u as=0.65p ps=3.3u w=1u l=0.28u
X836 a_19894_36400# a_17308_37600# a_19708_37600# start nfet_03v3 ad=0.305p pd=2.22u as=0.305p ps=2.22u w=0.5u l=0.28u
X837 start comp_out_p comp_out_p start pfet_03v3 ad=1.38p pd=4.76u as=0.65p ps=3.3u w=1u l=0.28u
X838 start a_39708_24800# rst_latch start pfet_03v3 ad=1.38p pd=4.76u as=0.65p ps=3.3u w=1u l=0.28u
X839 start a_48908_12400# a_50108_12400# start nfet_03v3 ad=0.66p pd=3.64u as=0.305p ps=2.22u w=0.5u l=0.28u
X840 start dout[7] a_49708_41600# start nfet_03v3 ad=0.577p pd=3.52u as=0.2646p ps=2.1u w=0.42u l=0.28u
X841 start a_33308_1200# a_34508_1200# start nfet_03v3 ad=0.66p pd=3.64u as=0.305p ps=2.22u w=0.5u l=0.28u
X842 a_35494_32400# comp_out_p comp_out_p start nfet_03v3 ad=0.305p pd=2.22u as=0.305p ps=2.22u w=0.5u l=0.28u
X843 start a_36908_6800# a_38108_6800# start nfet_03v3 ad=0.66p pd=3.64u as=0.305p ps=2.22u w=0.5u l=0.28u
X844 a_5708_10960# a_2108_10960# a_8108_10960# start nfet_03v3 ad=0.305p pd=2.22u as=0.305p ps=2.22u w=0.5u l=0.28u
X845 a_18508_10960# a_14908_10960# a_20908_10960# start nfet_03v3 ad=0.305p pd=2.22u as=0.305p ps=2.22u w=0.5u l=0.28u
X846 start a_22108_15760# a_20908_15760# start nfet_03v3 ad=0.577p pd=3.52u as=0.2646p ps=2.1u w=0.42u l=2.4u
X847 start a_45428_15064# a_44228_15064# start nfet_03v3 ad=0.66p pd=3.64u as=0.305p ps=2.22u w=0.5u l=0.28u
X848 start a_18508_46000# a_19708_46000# start nfet_03v3 ad=0.66p pd=3.64u as=0.305p ps=2.22u w=0.5u l=0.28u
X849 start start a_2908_29600# start pfet_03v3 ad=1.38p pd=4.76u as=0.65p ps=3.3u w=1u l=0.28u
X850 start a_9308_20560# a_8108_20560# start nfet_03v3 ad=0.577p pd=3.52u as=0.2646p ps=2.1u w=0.42u l=2.4u
X851 start a_52508_1200# a_53708_1200# start nfet_03v3 ad=0.66p pd=3.64u as=0.305p ps=2.22u w=0.5u l=0.28u
X852 start a_46508_1200# a_47708_1200# start pfet_03v3 ad=1.38p pd=4.76u as=0.65p ps=3.3u w=1u l=0.28u
X853 start a_52628_3864# a_51428_3864# start nfet_03v3 ad=0.66p pd=3.64u as=0.305p ps=2.22u w=0.5u l=0.28u
X854 start comp_out_p a_44908_50400# start pfet_03v3 ad=1.104p pd=4.36u as=0.52p ps=2.9u w=0.8u l=0.28u
X855 start a_51428_3864# a_50228_3864# start pfet_03v3 ad=1.38p pd=4.76u as=0.65p ps=3.3u w=1u l=0.28u
X856 start a_56228_9464# a_55028_9464# start pfet_03v3 ad=1.38p pd=4.76u as=0.65p ps=3.3u w=1u l=0.28u
X857 start a_3428_10824# a_3308_10960# start pfet_03v3 ad=1.38p pd=4.76u as=0.65p ps=3.3u w=1u l=0.28u
X858 start a_17708_54400# a_19094_53200# start nfet_03v3 ad=0.66p pd=3.64u as=0.305p ps=2.22u w=0.5u l=0.28u
X859 start start start start nfet_03v3 ad=0.2646p pd=2.1u as=0 ps=0 w=0.42u l=0.28u
X860 start comp_out_p comp_out_p start pfet_03v3 ad=1.38p pd=4.76u as=0.65p ps=3.3u w=1u l=0.28u
X861 start a_19708_29600# dout[0] start pfet_03v3 ad=1.104p pd=4.36u as=0.52p ps=2.9u w=0.8u l=0.28u
X862 start a_4508_20560# a_5708_20560# start pfet_03v3 ad=1.38p pd=4.76u as=0.65p ps=3.3u w=1u l=0.28u
X863 start start a_2908_33600# start nfet_03v3 ad=0.66p pd=3.64u as=0.305p ps=2.22u w=0.5u l=0.28u
X864 start a_49708_33600# a_50908_33600# start pfet_03v3 ad=1.38p pd=4.76u as=0.65p ps=3.3u w=1u l=0.28u
X865 a_3308_15760# a_2228_15624# a_4508_15760# start nfet_03v3 ad=0.305p pd=2.22u as=0.305p ps=2.22u w=0.5u l=0.28u
X866 start a_56108_12400# a_57308_12400# start pfet_03v3 ad=1.38p pd=4.76u as=0.65p ps=3.3u w=1u l=0.28u
X867 start a_52628_9464# a_51428_9464# start nfet_03v3 ad=0.66p pd=3.64u as=0.305p ps=2.22u w=0.5u l=0.28u
X868 start a_41828_9464# a_40628_9464# start pfet_03v3 ad=1.38p pd=4.76u as=0.65p ps=3.3u w=1u l=0.28u
X869 start comp_out_p a_35494_40400# start nfet_03v3 ad=0.66p pd=3.64u as=0.305p ps=2.22u w=0.5u l=0.28u
X870 start a_19708_33600# dout[1] start nfet_03v3 ad=0.577p pd=3.52u as=0.2646p ps=2.1u w=0.42u l=0.28u
X871 a_18508_15760# a_15028_15624# a_20908_15760# start pfet_03v3 ad=0.65p pd=3.3u as=0.65p ps=3.3u w=1u l=0.28u
X872 start start start start pfet_03v3 ad=0.2822p pd=2.18u as=0 ps=0 w=0.42u l=2u
X873 start a_14908_46000# a_16108_46000# start pfet_03v3 ad=1.38p pd=4.76u as=0.65p ps=3.3u w=1u l=0.28u
X874 start a_57428_3864# a_56228_3864# start nfet_03v3 ad=0.66p pd=3.64u as=0.305p ps=2.22u w=0.5u l=0.28u
X875 start a_24508_54400# a_25894_53200# start nfet_03v3 ad=0.66p pd=3.64u as=0.305p ps=2.22u w=0.5u l=0.28u
X876 start start a_38108_54400# start nfet_03v3 ad=0.577p pd=3.52u as=0.2646p ps=2.1u w=0.42u l=0.28u
X877 start a_56228_3864# a_55028_3864# start pfet_03v3 ad=1.38p pd=4.76u as=0.65p ps=3.3u w=1u l=0.28u
X878 start a_4508_15760# a_5708_15760# start pfet_03v3 ad=1.38p pd=4.76u as=0.65p ps=3.3u w=1u l=0.28u
X879 start a_2228_1424# start start nfet_03v3 ad=0.2646p pd=2.1u as=0 ps=0 w=0.42u l=0.28u
X880 start comp_out_p comp_out_p start pfet_03v3 ad=1.38p pd=4.76u as=0.65p ps=3.3u w=1u l=0.28u
X881 start dout[1] a_11308_33600# start pfet_03v3 ad=1.104p pd=4.36u as=0.52p ps=2.9u w=0.8u l=0.28u
X882 start a_59708_6800# a_60908_6800# start nfet_03v3 ad=0.66p pd=3.64u as=0.305p ps=2.22u w=0.5u l=0.28u
X883 start a_50908_29600# dout[4] start nfet_03v3 ad=0.577p pd=3.52u as=0.2646p ps=2.1u w=0.42u l=0.28u
X884 start a_48908_6800# a_50108_6800# start pfet_03v3 ad=1.38p pd=4.76u as=0.65p ps=3.3u w=1u l=0.28u
X885 start start a_34108_37600# start nfet_03v3 ad=0.66p pd=3.64u as=0.305p ps=2.22u w=0.5u l=0.28u
X886 start a_51708_50400# a_50628_54264# start pfet_03v3 ad=1.38p pd=4.76u as=0.65p ps=3.3u w=1u l=0.28u
X887 start a_37028_3864# a_35828_3864# start nfet_03v3 ad=0.66p pd=3.64u as=0.305p ps=2.22u w=0.5u l=0.28u
X888 start a_53708_12400# a_54908_12400# start nfet_03v3 ad=0.66p pd=3.64u as=0.305p ps=2.22u w=0.5u l=0.28u
X889 a_16108_6160# a_15028_6024# a_17308_6160# start nfet_03v3 ad=0.305p pd=2.22u as=0.305p ps=2.22u w=0.5u l=0.28u
X890 start a_38108_54400# a_39494_53200# start nfet_03v3 ad=0.66p pd=3.64u as=0.305p ps=2.22u w=0.5u l=0.28u
X891 start start a_51708_54400# start nfet_03v3 ad=0.577p pd=3.52u as=0.2646p ps=2.1u w=0.42u l=0.28u
X892 start comp_out_p comp_out_p start nfet_03v3 ad=0.66p pd=3.64u as=0.305p ps=2.22u w=0.5u l=0.28u
X893 start dout[4] a_42508_29600# start pfet_03v3 ad=1.104p pd=4.36u as=0.52p ps=2.9u w=0.8u l=0.28u
X894 start comp_done a_43094_18000# start nfet_03v3 ad=0.66p pd=3.64u as=0.305p ps=2.22u w=0.5u l=0.28u
X895 start a_57428_9464# a_56228_9464# start nfet_03v3 ad=0.66p pd=3.64u as=0.305p ps=2.22u w=0.5u l=0.28u
X896 start a_41828_3864# a_40628_3864# start pfet_03v3 ad=1.38p pd=4.76u as=0.65p ps=3.3u w=1u l=0.28u
X897 start a_46628_9464# a_45428_9464# start pfet_03v3 ad=1.38p pd=4.76u as=0.65p ps=3.3u w=1u l=0.28u
X898 a_4294_40400# comp_out_p a_4108_41600# start nfet_03v3 ad=0.305p pd=2.22u as=0.305p ps=2.22u w=0.5u l=0.28u
X899 start a_53708_1200# a_54908_1200# start nfet_03v3 ad=0.66p pd=3.64u as=0.305p ps=2.22u w=0.5u l=0.28u
C0 a_22294_14400# a_20908_15760# 0.05987f
C1 a_34108_33600# a_35308_29600# 0.11586f
C2 a_19708_46000# a_20908_46000# 0.92654f
C3 done a_34108_37600# 0.02619f
C4 a_39308_6800# a_40508_6800# 1.00762f
C5 a_43828_54264# a_20908_46000# 0.18658f
C6 dac_in[7] a_33308_19200# 0.06756f
C7 a_42908_1200# a_45308_1200# 0.04266f
C8 a_33308_19200# a_30228_54264# 0.16401f
C9 a_46628_3864# sample_en 0.91292f
C10 comp_out_p a_36908_54400# 0.08922f
C11 dout[5] a_49708_37600# 0.0722f
C12 comp_out_p a_2108_10960# 0.03507f
C13 a_47028_19064# a_16628_54264# 0.12835f
C14 dout[6] a_23428_54264# 0.12915f
C15 a_9828_54264# comp_out_p 4.88535f
C16 done dac_in[6] 0.12286f
C17 comp_done dac_in[7] 0.07032f
C18 dout[5] a_51094_36400# 0.0134f
C19 dout[6] dout[7] 30.8291f
C20 a_17308_33600# a_19708_33600# 0.99858f
C21 a_47708_12400# a_50108_12400# 0.04266f
C22 comp_done a_30228_54264# 0.2692f
C23 a_17308_15760# a_18508_15760# 1.81793f
C24 done a_50628_54264# 0.20219f
C25 comp_out_p a_37028_54264# 1.34672f
C26 a_33308_19200# a_2908_41600# 0.01463f
C27 dout[1] a_20908_46000# 0.12157f
C28 a_53828_9464# a_55028_9464# 0.90775f
C29 a_59708_1200# a_57308_1200# 0.04266f
C30 a_54908_1200# a_56108_1200# 1.00702f
C31 a_53708_6800# a_56108_6800# 0.04266f
C32 rst_latch a_42294_23600# 0.03268f
C33 a_38108_6800# a_40508_6800# 0.04266f
C34 dout[2] a_16628_54264# 3.42041f
C35 dac_in[4] dac_in[5] 25.6598f
C36 a_42908_1200# a_44108_1200# 1.00702f
C37 dac_in[0] a_2908_54400# 0.99858f
C38 a_42908_19200# a_43094_18000# 0.042f
C39 dout[7] a_53094_53200# 0.01107f
C40 comp_out_p a_3028_54264# 6.70725f
C41 dout[2] a_10108_41600# 0.05122f
C42 dac_in[6] dac_in[0] 0.06032f
C43 a_33308_19200# a_2228_15624# 0.02937f
C44 dac_in[0] a_50628_54264# 0.12656f
C45 comp_out_p a_33308_24800# 11.5727f
C46 dout[5] a_48508_37600# 0.12453f
C47 a_47028_19064# a_50508_54400# 0.02304f
C48 comp_out_p a_2908_50400# 0.0238f
C49 comp_out_p a_17708_50400# 1.03578f
C50 a_16108_15760# a_35308_29600# 0.03541f
C51 a_10108_46000# a_7708_46000# 0.04266f
C52 done a_35708_24800# 0.01607f
C53 a_33308_19200# a_20908_46000# 0.13245f
C54 a_47708_12400# a_48908_12400# 1.00702f
C55 a_14908_15760# a_18508_15760# 0.4841f
C56 a_17308_15760# a_16108_15760# 0.2837f
C57 a_9828_54264# done 0.12835f
C58 comp_out_p a_18508_37600# 0.07684f
C59 a_53708_1200# a_56108_1200# 0.04266f
C60 a_53708_6800# a_54908_6800# 1.00762f
C61 dout[1] a_43828_54264# 0.1156f
C62 done a_37028_54264# 0.12595f
C63 comp_done a_20908_46000# 0.13245f
C64 a_38108_6800# a_39308_6800# 1.00702f
C65 dac_in[7] a_47028_19064# 0.06765f
C66 a_47028_19064# a_30228_54264# 0.13273f
C67 sample_en a_16628_54264# 0.24993f
C68 a_41708_1200# a_44108_1200# 0.04266f
C69 a_18508_1360# a_18628_1224# 1.05947f
C70 a_3308_15760# a_4508_15760# 0.2837f
C71 dout[2] a_7708_41600# 0.01285f
C72 a_51094_28400# a_50908_29600# 0.03264f
C73 comp_out_p a_16508_50400# 0.07438f
C74 dac_in[5] a_23428_54264# 0.13593f
C75 dout[5] a_43708_37600# 0.03546f
C76 a_9828_54264# dac_in[0] 0.38398f
C77 done a_3028_54264# 0.12157f
C78 dout[7] dac_in[5] 0.06109f
C79 a_11308_37600# a_12508_37600# 0.76551f
C80 a_8908_46000# a_7708_46000# 1.00702f
C81 done a_33308_24800# 1.24959f
C82 dac_in[0] a_37028_54264# 0.12915f
C83 dac_in[6] dout[3] 0.05879f
C84 dout[0] comp_out_p 2.99553f
C85 dac_in[7] dout[2] 0.06119f
C86 a_46508_12400# a_48908_12400# 0.04266f
C87 comp_done a_43094_18000# 0.01847f
C88 a_14908_15760# a_16108_15760# 1.39926f
C89 dout[2] a_30228_54264# 0.12238f
C90 comp_out_p a_17308_37600# 1.03344f
C91 dout[7] a_34108_41600# 0.09997f
C92 a_33308_19200# a_43828_54264# 0.12749f
C93 dout[5] a_50508_50400# 0.0187f
C94 dout[3] a_50628_54264# 0.12065f
C95 a_53708_1200# a_54908_1200# 1.00762f
C96 a_52628_9464# a_53828_9464# 0.90778f
C97 a_59708_1200# a_60908_1200# 0.96154f
C98 a_52508_6800# a_54908_6800# 0.04266f
C99 dac_in[1] a_16628_54264# 0.12915f
C100 rst_latch a_40908_24800# 0.80903f
C101 a_9828_54264# a_10908_50400# 0.81014f
C102 a_20908_46000# a_38908_41600# 0.02366f
C103 comp_done a_43828_54264# 1.40972f
C104 dac_in[0] a_3028_54264# 3.04971f
C105 a_41708_1200# a_42908_1200# 1.00762f
C106 dac_in[0] a_33308_24800# 0.12157f
C107 a_3308_15760# a_2108_15760# 1.39926f
C108 a_51094_28400# a_49708_29600# 0.0129f
C109 dout[5] a_42508_37600# 0.04175f
C110 dout[1] a_33308_19200# 0.12157f
C111 dout[0] a_17308_41600# 0.0327f
C112 a_10108_37600# a_12508_37600# 0.99858f
C113 a_8908_46000# a_6508_46000# 0.04266f
C114 a_47028_19064# a_20908_46000# 0.12771f
C115 a_46508_12400# a_47708_12400# 1.00762f
C116 a_16228_15624# a_16108_15760# 1.05947f
C117 a_15028_15624# a_18508_15760# 0.76262f
C118 comp_done a_42908_19200# 0.48597f
C119 a_16108_46000# a_35308_29600# 0.04535f
C120 a_5494_49200# a_4108_50400# 0.0129f
C121 comp_out_p a_12508_37600# 0.01615f
C122 a_52508_1200# a_54908_1200# 0.04266f
C123 comp_done dout[1] 0.12157f
C124 done dout[0] 0.12157f
C125 rst_latch a_39708_24800# 0.99858f
C126 rst_latch dac_in[6] 0.1281f
C127 sample_en dac_in[7] 0.17977f
C128 a_52508_6800# a_53708_6800# 1.00702f
C129 a_9828_54264# dout[3] 0.12675f
C130 a_9828_54264# a_9708_50400# 0.99875f
C131 sample_en a_30228_54264# 0.25867f
C132 a_44908_54400# a_46294_53200# 0.0129f
C133 rst_latch a_50628_54264# 0.13448f
C134 dout[3] a_37028_54264# 0.12238f
C135 comp_out_p a_2908_46000# 0.02787f
C136 dout[2] a_20908_46000# 0.12341f
C137 a_33308_24800# a_43894_40400# 0.01137f
C138 a_40508_1200# a_42908_1200# 0.04266f
C139 a_43708_50400# a_20908_46000# 0.02107f
C140 a_33308_24800# a_43708_29600# 0.0362f
C141 a_3308_15760# a_3428_15624# 1.05947f
C142 dout[4] a_16628_54264# 0.12915f
C143 dout[4] a_51094_32400# 0.01941f
C144 comp_out_p a_35494_28400# 0.01992f
C145 a_50508_54400# a_51708_54400# 0.42392f
C146 dout[5] a_41308_37600# 0.05122f
C147 a_10108_37600# a_11308_37600# 0.42399f
C148 dout[3] a_3028_54264# 0.12915f
C149 dac_in[7] dac_in[1] 0.06119f
C150 dout[0] dac_in[0] 0.08402f
C151 dac_in[6] dac_in[2] 0.06041f
C152 dac_in[1] a_30228_54264# 0.12915f
C153 comp_done a_33308_19200# 1.01622f
C154 a_45308_12400# a_47708_12400# 0.04266f
C155 a_15028_15624# a_16108_15760# 0.25574f
C156 dout[3] a_33308_24800# 0.2567f
C157 dac_in[2] a_50628_54264# 0.12656f
C158 dout[3] a_17708_50400# 0.01279f
C159 comp_out_p a_11308_37600# 0.01774f
C160 a_47028_19064# a_43828_54264# 0.40085f
C161 a_52508_1200# a_53708_1200# 1.00702f
C162 a_51428_9464# a_52628_9464# 0.90775f
C163 comp_out_p a_4294_28400# 0.0636f
C164 a_51308_6800# a_53708_6800# 0.04266f
C165 dac_in[7] a_51708_54400# 0.80903f
C166 a_9828_54264# rst_latch 0.12835f
C167 a_40508_1200# a_41708_1200# 1.00702f
C168 a_19094_49200# a_16628_54264# 0.03268f
C169 dout[0] a_16508_54400# 0.01819f
C170 a_47028_19064# a_42908_19200# 0.01361f
C171 dout[2] a_43828_54264# 0.1156f
C172 dout[4] a_50508_54400# 0.01772f
C173 rst_latch a_37028_54264# 0.12595f
C174 a_3308_15760# a_2228_15624# 0.25574f
C175 comp_done a_4108_50400# 0.02742f
C176 sample_en a_20908_46000# 15.4127f
C177 a_33308_24800# a_42508_29600# 0.05997f
C178 a_43828_54264# a_43708_50400# 0.99858f
C179 a_20908_46000# a_43708_41600# 0.03128f
C180 dout[1] a_47028_19064# 0.12157f
C181 a_2908_37600# a_11308_37600# 0.04546f
C182 a_44228_9464# a_45428_9464# 0.90775f
C183 a_45308_12400# a_46508_12400# 1.00702f
C184 dout[3] a_16508_50400# 0.02601f
C185 comp_out_p a_10108_37600# 0.10239f
C186 a_9828_54264# dac_in[2] 0.13507f
C187 a_55028_9464# sample_en 0.01137f
C188 rst_latch a_3028_54264# 0.12157f
C189 a_51308_1200# a_53708_1200# 0.04266f
C190 a_51308_6800# a_52508_6800# 1.00762f
C191 rst_latch a_33308_24800# 0.47253f
C192 a_9494_14400# a_9308_15760# 0.03324f
C193 dac_in[2] a_37028_54264# 0.12915f
C194 dac_in[1] a_20908_46000# 0.06079f
C195 dac_in[6] dout[5] 0.12086f
C196 dout[0] dout[3] 0.24079f
C197 dout[1] dout[2] 31.125f
C198 dac_in[7] dout[4] 0.06317f
C199 a_2228_10824# a_33308_19200# 0.02937f
C200 dout[4] a_30228_54264# 3.52758f
C201 a_47028_19064# a_51708_50400# 0.01926f
C202 dout[7] a_50508_50400# 1.02198f
C203 dout[5] a_50628_54264# 0.18097f
C204 comp_done a_38908_41600# 0.01176f
C205 comp_done a_4108_54400# 0.02742f
C206 dac_in[3] a_16628_54264# 0.13593f
C207 a_39308_1200# a_41708_1200# 0.04266f
C208 a_35308_29600# a_16628_54264# 0.16241f
C209 a_47028_19064# a_33308_19200# 0.12749f
C210 a_54908_6800# sample_en 0.01711f
C211 a_19708_1360# a_18628_1224# 0.04931f
C212 a_33308_24800# a_41308_29600# 0.03611f
C213 a_43894_28400# a_43708_29600# 0.03264f
C214 a_20908_46000# a_42508_41600# 0.0117f
C215 sample_en a_43828_54264# 0.71537f
C216 dac_in[2] a_3028_54264# 0.13507f
C217 a_2908_37600# a_10108_37600# 1.00249f
C218 a_43708_54400# a_20908_46000# 0.0181f
C219 comp_out_p a_19094_53200# 0.0188f
C220 dac_in[2] a_33308_24800# 0.13513f
C221 a_44108_12400# a_46508_12400# 0.04266f
C222 comp_done a_47028_19064# 2.46555f
C223 comp_out_p a_2908_37600# 1.90103f
C224 a_9308_15760# a_11708_15760# 1.03812f
C225 comp_out_p a_17308_41600# 0.03038f
C226 a_2228_10824# a_3428_10824# 0.03237f
C227 a_53828_9464# sample_en 0.05234f
C228 dout[2] a_33308_19200# 0.12341f
C229 a_51308_1200# a_52508_1200# 1.00762f
C230 a_50228_9464# a_51428_9464# 0.90778f
C231 a_49708_29600# a_50908_29600# 0.76551f
C232 a_50108_6800# a_52508_6800# 0.04266f
C233 done a_50908_29600# 0.0288f
C234 dac_in[1] a_43828_54264# 0.12905f
C235 done comp_out_p 1.99767f
C236 comp_done dout[2] 0.12341f
C237 sample_en dout[1] 0.24315f
C238 a_9828_54264# dout[5] 0.12675f
C239 rst_latch dout[0] 0.12157f
C240 a_39308_1200# a_40508_1200# 1.00762f
C241 a_17308_1360# a_18628_1224# 0.02521f
C242 dout[1] a_9708_54400# 0.01848f
C243 a_53708_6800# sample_en 0.0461f
C244 a_33308_24800# a_34108_29600# 0.23506f
C245 a_43894_28400# a_42508_29600# 0.0129f
C246 dout[5] a_37028_54264# 3.7244f
C247 dout[4] a_20908_46000# 0.17416f
C248 a_35308_29600# a_7708_41600# 0.03152f
C249 a_43028_9464# a_44228_9464# 0.90778f
C250 a_44108_12400# a_45308_12400# 1.00762f
C251 dout[6] a_16628_54264# 0.12915f
C252 a_55028_3864# a_56228_3864# 0.90778f
C253 a_43708_54400# a_43828_54264# 1.00906f
C254 a_10628_15624# a_11708_15760# 0.04888f
C255 a_43828_54264# a_51708_54400# 0.06426f
C256 a_47028_19064# a_38908_41600# 0.15854f
C257 a_52628_9464# sample_en 0.01026f
C258 comp_out_p a_12508_41600# 0.01824f
C259 sample_en a_51708_50400# 0.01897f
C260 a_16108_10960# a_18508_10960# 0.06606f
C261 a_48508_29600# a_50908_29600# 0.99858f
C262 a_50108_1200# a_52508_1200# 0.04266f
C263 dout[0] dac_in[2] 0.06141f
C264 dac_in[7] dac_in[3] 0.06127f
C265 dout[5] a_3028_54264# 0.12915f
C266 comp_out_p dac_in[0] 1.00548f
C267 dout[1] dac_in[1] 0.08964f
C268 a_50108_6800# a_51308_6800# 1.00702f
C269 dac_in[6] dac_in[4] 0.06072f
C270 dac_in[7] a_35308_29600# 0.06119f
C271 dac_in[3] a_30228_54264# 0.12915f
C272 dout[5] a_33308_24800# 3.49851f
C273 sample_en a_33308_19200# 0.26103f
C274 a_18508_33600# a_19894_32400# 0.0129f
C275 a_35308_29600# a_30228_54264# 0.11997f
C276 dac_in[4] a_50628_54264# 0.12656f
C277 done a_49708_29600# 0.02319f
C278 a_38108_1200# a_40508_1200# 0.04266f
C279 a_52508_6800# sample_en 0.01311f
C280 a_35494_32400# a_35308_29600# 0.01905f
C281 comp_out_p a_10908_50400# 1.07137f
C282 comp_done sample_en 15.1267f
C283 comp_out_p a_16508_54400# 0.02217f
C284 dout[6] a_50508_54400# 0.02432f
C285 a_44908_54400# dac_in[6] 0.80903f
C286 dout[4] a_43828_54264# 0.17764f
C287 a_42908_12400# a_45308_12400# 0.04266f
C288 dac_in[1] a_33308_19200# 0.06079f
C289 done a_48508_41600# 0.01843f
C290 comp_out_p a_7708_46000# 0.12179f
C291 comp_out_p a_11308_41600# 0.02874f
C292 a_50108_1200# a_51308_1200# 1.00702f
C293 dout[2] a_47028_19064# 0.12341f
C294 a_49028_9464# a_50228_9464# 0.90775f
C295 a_48508_29600# a_49708_29600# 0.42399f
C296 a_43708_33600# a_33308_24800# 0.0362f
C297 a_36908_6800# a_39308_6800# 0.04266f
C298 comp_done dac_in[1] 0.06079f
C299 done dac_in[0] 0.06079f
C300 a_9828_54264# dac_in[4] 0.13507f
C301 done a_48508_29600# 0.01843f
C302 a_38108_1200# a_39308_1200# 1.00702f
C303 a_46628_9464# a_45428_9464# 0.90778f
C304 dac_in[4] a_37028_54264# 0.12915f
C305 dac_in[6] a_23428_54264# 0.13593f
C306 comp_out_p dout[3] 5.51066f
C307 dout[0] dout[5] 0.1156f
C308 dac_in[6] dout[7] 0.89156f
C309 dac_in[7] dout[6] 0.07964f
C310 dout[1] dout[4] 0.12274f
C311 a_9308_15760# a_8108_15760# 2.73702f
C312 dac_in[3] a_20908_46000# 0.06756f
C313 dout[6] a_30228_54264# 0.12915f
C314 a_20908_46000# a_35308_29600# 1.08069f
C315 a_23428_54264# a_50628_54264# 0.13427f
C316 comp_out_p a_9708_50400# 0.12922f
C317 dout[7] a_50628_54264# 3.97166f
C318 sample_en a_38908_41600# 0.04374f
C319 dac_in[5] a_16628_54264# 0.13593f
C320 a_17708_54400# a_16628_54264# 0.04977f
C321 comp_out_p a_4294_32400# 0.08198f
C322 dout[0] a_19708_29600# 1.09035f
C323 a_41828_9464# a_43028_9464# 0.90775f
C324 a_42908_12400# a_44108_12400# 1.00702f
C325 comp_out_p a_6508_46000# 0.0953f
C326 dac_in[4] a_3028_54264# 0.13515f
C327 comp_out_p a_35494_40400# 0.03751f
C328 a_48908_1200# a_51308_1200# 0.04266f
C329 comp_out_p a_4294_40400# 0.03751f
C330 dac_in[7] a_53094_53200# 0.03268f
C331 dout[1] a_18508_33600# 1.03879f
C332 dac_in[4] a_33308_24800# 0.1748f
C333 dout[4] a_51708_50400# 0.02765f
C334 a_44908_54400# a_37028_54264# 0.0446f
C335 sample_en a_47028_19064# 0.32182f
C336 a_36908_6800# a_38108_6800# 1.00762f
C337 a_42508_33600# a_33308_24800# 0.05968f
C338 a_9494_19200# a_9308_20560# 0.03324f
C339 dout[3] a_17308_41600# 0.03674f
C340 dout[4] a_33308_19200# 0.12835f
C341 a_36908_1200# a_39308_1200# 0.04266f
C342 a_5708_10960# a_2228_10824# 0.76262f
C343 a_3308_10960# a_3428_10824# 1.05947f
C344 a_10628_15624# a_8108_15760# 0.08029f
C345 comp_out_p a_18508_6160# 0.05147f
C346 dout[1] a_10908_54400# 0.02186f
C347 dac_in[3] a_43828_54264# 0.12905f
C348 a_9828_54264# a_23428_54264# 0.13674f
C349 rst_latch comp_out_p 3.24734f
C350 sample_en dout[2] 0.24682f
C351 done dout[3] 0.12835f
C352 a_9828_54264# dout[7] 0.12675f
C353 comp_done dout[4] 0.37842f
C354 a_43828_54264# a_35308_29600# 0.17964f
C355 sample_en a_43708_50400# 0.0333f
C356 a_11308_41600# a_12508_41600# 0.76551f
C357 a_12694_40400# a_12508_41600# 0.03264f
C358 a_37028_54264# a_23428_54264# 0.13674f
C359 dout[7] a_37028_54264# 0.12915f
C360 dac_in[1] a_47028_19064# 0.06079f
C361 a_41708_12400# a_44108_12400# 0.04266f
C362 dout[6] a_20908_46000# 0.2267f
C363 a_3308_20560# a_5708_20560# 0.06606f
C364 a_9308_20560# a_11708_20560# 1.00563f
C365 a_59708_12400# a_60908_12400# 0.96154f
C366 a_47828_9464# a_49028_9464# 0.90778f
C367 a_22108_10960# a_24508_10960# 1.03812f
C368 a_48908_1200# a_50108_1200# 1.00762f
C369 dout[1] a_17308_33600# 0.03674f
C370 a_35708_6800# a_38108_6800# 0.04266f
C371 a_41308_33600# a_33308_24800# 0.03222f
C372 dout[3] a_12508_41600# 1.09037f
C373 comp_out_p dac_in[2] 0.4245f
C374 dout[1] dac_in[3] 0.06119f
C375 dout[0] dac_in[4] 0.06119f
C376 dac_in[7] dac_in[5] 0.06159f
C377 a_23428_54264# a_3028_54264# 0.1363f
C378 dout[3] dac_in[0] 0.05879f
C379 dout[2] dac_in[1] 0.06119f
C380 a_36908_1200# a_38108_1200# 1.00762f
C381 a_47028_19064# a_51708_54400# 0.01844f
C382 dout[7] a_3028_54264# 0.12915f
C383 dac_in[5] a_30228_54264# 0.13593f
C384 dout[1] a_35308_29600# 0.1666f
C385 dout[1] a_12294_49200# 0.01043f
C386 dout[7] a_33308_24800# 0.43817f
C387 a_3308_10960# a_2228_10824# 0.25574f
C388 comp_out_p a_16108_6160# 0.02558f
C389 a_33308_24800# a_23428_54264# 0.26545f
C390 rst_latch a_49708_29600# 0.037f
C391 sample_en a_38108_50400# 0.02811f
C392 comp_out_p a_49708_33600# 0.04546f
C393 a_40628_9464# a_41828_9464# 0.90778f
C394 a_41708_12400# a_42908_12400# 1.00762f
C395 a_12694_40400# a_11308_41600# 0.0129f
C396 a_33428_9464# a_34628_9464# 0.90778f
C397 done rst_latch 16.3074f
C398 dac_in[2] a_19094_53200# 0.03268f
C399 sample_en a_48908_1200# 0.05155f
C400 a_59828_15064# a_61028_15064# 0.90066f
C401 sample_en a_43708_41600# 0.0288f
C402 a_9708_50400# a_10908_50400# 0.42392f
C403 a_58508_12400# a_60908_12400# 0.0395f
C404 a_23428_10824# a_24508_10960# 0.04888f
C405 done a_50908_33600# 0.0288f
C406 a_10628_20424# a_11708_20560# 0.04542f
C407 a_47708_1200# a_50108_1200# 0.04266f
C408 a_24508_54400# a_23308_54400# 0.42392f
C409 dout[6] a_43828_54264# 3.84193f
C410 dout[3] a_16508_54400# 0.02601f
C411 dout[1] a_12508_33600# 1.09037f
C412 comp_out_p a_34108_29600# 0.05094f
C413 dac_in[3] a_33308_19200# 0.06756f
C414 a_34108_33600# a_33308_24800# 0.23155f
C415 done a_50908_41600# 0.0288f
C416 a_9494_19200# a_8108_20560# 0.05987f
C417 rst_latch a_48508_41600# 0.02515f
C418 dout[4] a_47028_19064# 6.23051f
C419 a_33308_19200# a_35308_29600# 0.18857f
C420 dout[3] a_11308_41600# 1.03879f
C421 a_35708_1200# a_38108_1200# 0.04266f
C422 a_19894_28400# a_19708_29600# 0.03264f
C423 rst_latch dac_in[0] 0.06079f
C424 a_48508_41600# a_50908_41600# 0.99858f
C425 sample_en dac_in[1] 0.12157f
C426 comp_done dac_in[3] 0.06893f
C427 done dac_in[2] 0.06756f
C428 comp_done a_35308_29600# 0.20788f
C429 dac_in[3] a_24508_54400# 0.80903f
C430 rst_latch a_48508_29600# 0.03785f
C431 dac_in[1] a_9708_54400# 0.99858f
C432 a_6508_46000# a_7708_46000# 1.00762f
C433 a_43828_54264# a_53094_53200# 0.01615f
C434 dout[0] dout[7] 0.1132f
C435 dout[2] dout[4] 0.12318f
C436 comp_out_p dout[5] 2.61771f
C437 comp_out_p a_48508_33600# 1.00186f
C438 dout[0] a_23428_54264# 0.12238f
C439 dout[1] dout[6] 0.11474f
C440 a_51094_40400# a_50908_41600# 0.03264f
C441 dac_in[5] a_20908_46000# 0.12286f
C442 a_14908_6160# comp_out_p 0.06957f
C443 a_40508_12400# a_42908_12400# 0.04266f
C444 sample_en a_42508_41600# 0.0229f
C445 a_58508_12400# a_59708_12400# 1.0077f
C446 done a_49708_33600# 0.02273f
C447 a_47708_1200# a_48908_1200# 1.00702f
C448 a_8108_20560# a_11708_20560# 0.03504f
C449 a_42508_41600# a_43708_41600# 0.76551f
C450 a_42508_29600# a_43708_29600# 0.76551f
C451 a_46628_9464# a_47828_9464# 0.90775f
C452 a_14908_46000# comp_out_p 0.07153f
C453 dout[1] a_11308_33600# 1.03879f
C454 sample_en a_51708_54400# 0.01776f
C455 comp_out_p a_19708_29600# 0.01936f
C456 a_43828_54264# a_46294_49200# 0.03268f
C457 sample_en a_43708_54400# 0.03283f
C458 done a_49708_41600# 0.02273f
C459 a_33308_19200# a_2108_20560# 0.02806f
C460 dac_in[0] dac_in[2] 0.06159f
C461 done a_34108_29600# 0.02619f
C462 a_35708_1200# a_36908_1200# 1.00702f
C463 dout[6] a_51708_50400# 0.01837f
C464 comp_out_p a_5708_6160# 0.0894f
C465 a_9308_15760# a_2228_15624# 0.07546f
C466 a_48508_41600# a_49708_41600# 0.42399f
C467 dout[6] a_33308_19200# 0.12157f
C468 a_35308_29600# a_38908_41600# 0.0235f
C469 a_51094_40400# a_49708_41600# 0.0129f
C470 dout[0] a_18508_29600# 1.03879f
C471 a_16228_6024# comp_out_p 0.01659f
C472 a_39308_12400# a_41708_12400# 0.04266f
C473 a_39428_9464# a_40628_9464# 0.90775f
C474 a_40508_12400# a_41708_12400# 1.00702f
C475 a_58628_15064# a_59828_15064# 0.90775f
C476 a_8108_20560# a_5708_20560# 0.46956f
C477 dac_in[5] a_43828_54264# 0.26093f
C478 dac_in[2] a_16508_54400# 0.99858f
C479 a_57308_12400# a_59708_12400# 0.04266f
C480 done a_48508_33600# 0.01843f
C481 sample_en a_41308_41600# 0.02104f
C482 a_41308_41600# a_43708_41600# 0.99858f
C483 rst_latch dout[3] 0.12835f
C484 done dout[5] 0.21603f
C485 sample_en dout[4] 0.29287f
C486 comp_done dout[6] 0.73861f
C487 a_3308_10960# a_5708_10960# 0.06606f
C488 a_41308_29600# a_43708_29600# 0.99858f
C489 a_13708_46000# comp_out_p 0.01514f
C490 a_33428_9464# a_33308_9600# 0.90385f
C491 dout[1] a_10108_33600# 0.03674f
C492 dac_in[3] a_47028_19064# 0.06756f
C493 a_18508_41600# a_7708_41600# 0.04546f
C494 a_47028_19064# a_35308_29600# 0.3557f
C495 a_33428_3864# a_33308_4000# 0.90385f
C496 comp_out_p a_3308_6160# 0.02929f
C497 dout[0] a_19708_33600# 0.03072f
C498 a_16108_10960# a_35308_29600# 0.03541f
C499 rst_latch a_42508_29600# 0.01008f
C500 comp_out_p dac_in[4] 0.69928f
C501 dout[3] dac_in[2] 0.09969f
C502 dout[1] dac_in[5] 0.06032f
C503 dout[5] dac_in[0] 0.05915f
C504 dout[2] dac_in[3] 0.06119f
C505 dout[4] dac_in[1] 0.06119f
C506 a_24508_10960# a_20908_10960# 0.04749f
C507 a_23308_50400# a_24508_50400# 0.42392f
C508 dout[1] a_17708_54400# 0.01884f
C509 dout[2] a_35308_29600# 2.85702f
C510 a_43708_50400# a_35308_29600# 0.02621f
C511 a_38108_50400# a_36908_50400# 0.42392f
C512 a_15028_6024# comp_out_p 0.08891f
C513 dout[0] a_17308_29600# 0.03674f
C514 a_39308_12400# a_40508_12400# 1.00762f
C515 a_10628_20424# a_9308_20560# 0.26034f
C516 a_4508_20560# a_5708_20560# 1.81793f
C517 a_57308_12400# a_58508_12400# 1.00702f
C518 a_41308_29600# a_42508_29600# 0.42399f
C519 a_41308_41600# a_42508_41600# 0.42399f
C520 dout[1] a_2908_33600# 0.09997f
C521 a_10908_54400# a_9708_54400# 0.42392f
C522 dout[4] a_51708_54400# 0.02711f
C523 a_33308_19200# a_2228_20424# 0.02937f
C524 dout[7] a_53094_49200# 0.01314f
C525 a_19708_41600# a_19894_40400# 0.03264f
C526 a_23428_15624# a_22108_15760# 0.26027f
C527 dac_in[5] a_33308_19200# 0.06079f
C528 dout[6] a_47028_19064# 3.43414f
C529 a_2228_1424# a_33308_19200# 0.03642f
C530 a_57428_9464# a_58628_9464# 0.90778f
C531 a_18508_10960# a_20908_10960# 0.46956f
C532 a_33308_19200# a_34108_41600# 0.01826f
C533 dac_in[1] a_10908_54400# 0.80903f
C534 a_16108_6160# a_18508_6160# 0.06606f
C535 a_38228_9464# a_39428_9464# 0.90778f
C536 a_38108_50400# a_35308_29600# 0.98945f
C537 a_38108_12400# a_39308_12400# 1.00702f
C538 a_38108_12400# a_40508_12400# 0.04266f
C539 dout[0] a_12508_29600# 1.09037f
C540 a_2908_33600# a_33308_19200# 0.01463f
C541 comp_done dac_in[5] 0.06079f
C542 done dac_in[4] 0.21454f
C543 sample_en dac_in[3] 0.13513f
C544 rst_latch dac_in[2] 0.06756f
C545 a_57428_15064# a_58628_15064# 0.90778f
C546 a_54908_12400# sample_en 0.01711f
C547 a_56108_12400# a_58508_12400# 0.04266f
C548 sample_en a_35308_29600# 0.61498f
C549 a_4508_20560# a_3308_20560# 0.2837f
C550 a_2108_20560# a_5708_20560# 0.4841f
C551 a_8108_20560# a_9308_20560# 2.73702f
C552 a_34108_29600# a_42508_29600# 0.04546f
C553 a_43708_37600# a_20908_46000# 0.03128f
C554 comp_out_p dout[7] 2.20367f
C555 dout[2] dout[6] 0.11491f
C556 dout[3] dout[5] 0.1164f
C557 comp_out_p a_23428_54264# 2.2938f
C558 comp_done a_34108_41600# 0.03041f
C559 dout[6] a_43708_50400# 1.01288f
C560 dout[0] a_17308_46000# 0.03722f
C561 rst_latch a_49708_33600# 0.03145f
C562 a_14908_46000# dout[3] 0.04148f
C563 a_18508_41600# a_19894_40400# 0.0129f
C564 a_55028_15064# sample_en 0.01137f
C565 a_49708_33600# a_50908_33600# 0.76551f
C566 a_20908_15760# a_22108_15760# 2.73702f
C567 dac_in[6] a_16628_54264# 0.13602f
C568 dac_in[1] dac_in[3] 0.06159f
C569 rst_latch a_49708_41600# 0.03145f
C570 dac_in[0] dac_in[4] 0.06127f
C571 a_19894_28400# a_18508_29600# 0.0129f
C572 a_50628_54264# a_16628_54264# 0.1341f
C573 dac_in[1] a_35308_29600# 0.0545f
C574 a_18508_10960# a_17308_10960# 1.81793f
C575 comp_out_p a_34108_33600# 1.65393f
C576 a_36908_12400# a_39308_12400# 0.04266f
C577 dout[0] a_11308_29600# 1.03879f
C578 a_49708_41600# a_50908_41600# 0.76551f
C579 a_53708_12400# sample_en 0.0461f
C580 a_56108_12400# a_57308_12400# 1.00762f
C581 a_8108_20560# a_10628_20424# 0.08029f
C582 a_2108_20560# a_3308_20560# 1.39926f
C583 a_42508_37600# a_20908_46000# 0.0117f
C584 a_34108_29600# a_41308_29600# 1.00249f
C585 comp_done a_49708_37600# 0.0193f
C586 sample_en a_38108_54400# 0.02811f
C587 a_12694_28400# a_12508_29600# 0.03264f
C588 comp_out_p a_18508_29600# 0.07684f
C589 a_14908_6160# a_18508_6160# 0.4841f
C590 a_34108_41600# a_38908_41600# 0.33005f
C591 a_43708_54400# a_35308_29600# 0.02324f
C592 dout[0] a_16108_46000# 0.01835f
C593 done dout[7] 0.30953f
C594 rst_latch dout[5] 0.3499f
C595 sample_en dout[6] 0.56584f
C596 rst_latch a_48508_33600# 0.02515f
C597 done a_23428_54264# 0.13273f
C598 comp_out_p a_18508_15760# 0.05074f
C599 a_20908_46000# a_44908_50400# 0.02716f
C600 dout[6] a_43708_41600# 0.03546f
C601 dout[5] a_50908_33600# 1.09035f
C602 a_48508_33600# a_50908_33600# 0.99858f
C603 a_53828_15064# sample_en 0.05234f
C604 a_47828_15064# a_49028_15064# 0.90778f
C605 dac_in[5] a_47028_19064# 0.06099f
C606 a_20908_15760# a_23428_15624# 0.08029f
C607 a_50508_54400# a_50628_54264# 1.00722f
C608 dout[7] a_48508_41600# 0.03674f
C609 dout[5] a_50908_41600# 0.02873f
C610 a_16108_10960# a_17308_10960# 0.2837f
C611 a_18508_10960# a_14908_10960# 0.4841f
C612 a_9828_54264# a_16628_54264# 25.736f
C613 a_5494_53200# a_4108_54400# 0.0129f
C614 a_47028_19064# a_50908_37600# 0.02013f
C615 comp_out_p a_19708_33600# 0.01936f
C616 dout[0] a_10108_29600# 0.03674f
C617 a_34508_1200# a_36908_1200# 0.04266f
C618 a_37028_9464# a_38228_9464# 0.90775f
C619 a_36908_12400# a_38108_12400# 1.00762f
C620 a_37028_54264# a_16628_54264# 0.1363f
C621 a_56228_15064# a_57428_15064# 0.90775f
C622 a_52508_12400# sample_en 0.01311f
C623 a_54908_12400# a_57308_12400# 0.04266f
C624 dout[7] dac_in[0] 25.6588f
C625 done a_34108_33600# 0.02619f
C626 dout[5] dac_in[2] 0.06119f
C627 dout[3] dac_in[4] 0.06119f
C628 dout[6] dac_in[1] 0.06155f
C629 dout[4] dac_in[3] 0.06119f
C630 dac_in[0] a_23428_54264# 0.12915f
C631 a_2228_20424# a_5708_20560# 0.76262f
C632 dout[2] dac_in[5] 0.06032f
C633 a_3428_20424# a_3308_20560# 1.05947f
C634 a_35308_29600# a_41308_41600# 0.03334f
C635 a_23428_10824# a_22108_10960# 0.26027f
C636 dout[4] a_35308_29600# 1.39873f
C637 dout[2] a_17708_54400# 0.02132f
C638 a_12694_28400# a_11308_29600# 0.0129f
C639 comp_done a_48508_37600# 0.03074f
C640 a_14908_6160# a_16108_6160# 1.39926f
C641 dac_in[6] dac_in[7] 25.6608f
C642 comp_out_p a_17308_29600# 1.03478f
C643 a_35708_6800# a_36908_6800# 1.00702f
C644 a_35308_41600# a_38908_41600# 1.36391f
C645 dac_in[6] a_30228_54264# 0.13593f
C646 dac_in[7] a_50628_54264# 3.64994f
C647 a_24508_1360# a_24694_0# 0.03324f
C648 comp_out_p a_16108_15760# 0.02485f
C649 a_17308_33600# a_18508_33600# 0.42399f
C650 dout[5] a_49708_33600# 1.03879f
C651 dout[6] a_42508_41600# 0.04175f
C652 a_48508_33600# a_49708_33600# 0.42399f
C653 a_50628_54264# a_30228_54264# 0.13446f
C654 a_3028_54264# a_16628_54264# 0.13674f
C655 a_52628_15064# sample_en 0.01026f
C656 comp_out_p a_17308_6160# 0.03909f
C657 a_25894_49200# a_23428_54264# 0.03268f
C658 a_43828_54264# a_44908_50400# 0.80903f
C659 a_33308_24800# a_16628_54264# 0.24993f
C660 dout[6] a_51708_54400# 0.01835f
C661 a_17708_50400# a_16628_54264# 0.80903f
C662 comp_out_p a_18508_46000# 0.03627f
C663 a_40908_24800# a_20908_46000# 0.04648f
C664 dout[5] a_49708_41600# 0.01521f
C665 a_9494_9600# a_9308_10960# 0.03324f
C666 a_16108_10960# a_14908_10960# 1.39926f
C667 a_47028_19064# a_49708_37600# 0.01969f
C668 a_22108_6160# a_24508_6160# 1.03812f
C669 a_34508_1200# a_35708_1200# 1.00762f
C670 a_35708_12400# a_38108_12400# 0.04266f
C671 dout[0] a_2908_29600# 0.09997f
C672 a_4508_6160# comp_out_p 0.02941f
C673 a_50508_50400# a_51708_50400# 0.42392f
C674 a_54908_12400# a_56108_12400# 1.00702f
C675 a_2228_20424# a_3308_20560# 0.25574f
C676 a_35308_29600# a_36908_50400# 0.04976f
C677 a_15028_6024# a_18508_6160# 0.76262f
C678 a_16228_6024# a_16108_6160# 1.05947f
C679 a_51708_54400# a_53094_53200# 0.0129f
C680 a_38108_50400# a_39494_49200# 0.0129f
C681 comp_out_p a_12508_29600# 0.01611f
C682 a_34508_6800# a_36908_6800# 0.04266f
C683 rst_latch dac_in[4] 0.06756f
C684 sample_en dac_in[5] 0.21432f
C685 a_36908_54400# a_30228_54264# 0.0406f
C686 dac_in[3] a_23308_54400# 0.99858f
C687 a_9828_54264# dac_in[7] 0.13547f
C688 dout[3] a_23428_54264# 3.56957f
C689 dout[3] dout[7] 0.11337f
C690 sample_en a_34108_41600# 0.02377f
C691 dout[4] dout[6] 0.20319f
C692 dout[6] a_41308_41600# 0.05122f
C693 dout[5] a_48508_33600# 0.03674f
C694 a_9828_54264# a_30228_54264# 0.1363f
C695 a_46628_15064# a_47828_15064# 0.90775f
C696 dac_in[7] a_37028_54264# 0.13593f
C697 a_16508_50400# a_16628_54264# 0.99858f
C698 dac_in[6] a_20908_46000# 0.06475f
C699 a_33308_24800# a_43894_32400# 0.01137f
C700 a_39708_24800# a_20908_46000# 1.01288f
C701 a_37028_54264# a_30228_54264# 25.845f
C702 a_18508_10960# a_15028_10824# 0.76262f
C703 a_47028_19064# a_48508_37600# 0.02674f
C704 a_16108_10960# a_16228_10824# 1.05947f
C705 a_20908_46000# a_50628_54264# 0.12595f
C706 a_23428_6024# a_24508_6160# 0.04888f
C707 a_35828_9464# a_37028_9464# 0.90778f
C708 a_35708_12400# a_36908_12400# 1.00702f
C709 dout[0] a_16628_54264# 3.14848f
C710 dac_in[2] dac_in[4] 0.06159f
C711 a_2108_6160# comp_out_p 0.03813f
C712 dac_in[1] dac_in[5] 0.06117f
C713 a_33308_1200# a_35708_1200# 0.04266f
C714 dac_in[3] a_35308_29600# 0.06119f
C715 a_55028_15064# a_56228_15064# 0.90778f
C716 a_53708_12400# a_56108_12400# 0.04266f
C717 a_2108_20560# a_8108_20560# 0.29742f
C718 a_2228_20424# a_9308_20560# 0.07546f
C719 dac_in[7] a_3028_54264# 25.7338f
C720 a_15028_6024# a_16108_6160# 0.25574f
C721 a_3028_54264# a_30228_54264# 0.1361f
C722 a_34508_6800# a_35708_6800# 1.00762f
C723 dac_in[7] a_33308_24800# 0.13513f
C724 dout[2] a_19708_41600# 0.03084f
C725 a_33308_24800# a_30228_54264# 0.29834f
C726 a_23308_1360# a_24694_0# 0.05987f
C727 comp_out_p a_5708_15760# 0.08566f
C728 dout[5] a_43708_33600# 1.09037f
C729 a_34108_41600# a_42508_41600# 0.04546f
C730 a_15028_15624# a_22108_15760# 0.07546f
C731 a_16228_6024# a_14908_6160# 0.02521f
C732 a_14908_15760# a_20908_15760# 0.29742f
C733 comp_out_p a_16108_46000# 0.02477f
C734 rst_latch a_23428_54264# 0.13273f
C735 rst_latch dout[7] 0.36306f
C736 a_16108_10960# a_15028_10824# 0.25574f
C737 a_22108_10960# a_20908_10960# 2.73702f
C738 a_9494_9600# a_8108_10960# 0.05987f
C739 dac_in[6] a_43828_54264# 3.47674f
C740 a_20908_6160# a_24508_6160# 0.04749f
C741 a_34508_12400# a_36908_12400# 0.04266f
C742 a_9828_54264# a_20908_46000# 0.12835f
C743 a_3428_6024# comp_out_p 0.02123f
C744 a_43828_54264# a_50628_54264# 26.0744f
C745 a_13708_46000# a_14908_46000# 1.00762f
C746 dout[7] a_50908_41600# 1.09035f
C747 a_53708_12400# a_54908_12400# 1.00762f
C748 a_2108_20560# a_4508_20560# 1.27786f
C749 a_20908_46000# a_37028_54264# 0.1883f
C750 a_47028_19064# a_50508_50400# 0.02377f
C751 dout[0] a_7708_41600# 0.07935f
C752 dout[2] a_18508_41600# 0.08797f
C753 a_33308_6800# a_35708_6800# 0.04266f
C754 a_2228_10824# a_9308_10960# 0.07546f
C755 a_14908_15760# a_35308_29600# 0.01927f
C756 dout[7] dac_in[2] 0.06155f
C757 dout[4] dac_in[5] 0.06032f
C758 dout[5] dac_in[4] 0.06119f
C759 dac_in[2] a_23428_54264# 0.12915f
C760 dout[6] dac_in[3] 0.06119f
C761 dout[6] a_35308_29600# 0.27519f
C762 dout[5] a_42508_33600# 1.03879f
C763 dac_in[7] dout[0] 0.06119f
C764 a_45428_15064# a_46628_15064# 0.90778f
C765 a_14908_15760# a_17308_15760# 1.27786f
C766 dac_in[6] dout[1] 0.05879f
C767 dout[0] a_30228_54264# 0.12238f
C768 dout[4] a_50908_37600# 0.02564f
C769 a_20908_46000# a_3028_54264# 0.12157f
C770 a_34108_41600# a_41308_41600# 1.00249f
C771 a_15028_6024# a_14908_6160# 3.2367f
C772 dout[1] a_50628_54264# 0.12065f
C773 a_33308_24800# a_20908_46000# 1.97815f
C774 a_33308_19200# a_34108_37600# 0.01826f
C775 a_23428_10824# a_20908_10960# 0.08029f
C776 a_3308_6160# a_5708_6160# 0.06606f
C777 a_20908_6160# a_18508_6160# 0.46956f
C778 a_34508_12400# a_35708_12400# 1.00762f
C779 a_2228_6024# comp_out_p 0.06215f
C780 a_34628_9464# a_35828_9464# 0.90775f
C781 a_2908_46000# a_4108_46000# 1.00709f
C782 dout[3] a_18508_46000# 0.03184f
C783 a_53828_15064# a_55028_15064# 0.90775f
C784 dout[1] a_19708_37600# 0.03072f
C785 dout[7] a_49708_41600# 1.03879f
C786 a_9828_54264# a_43828_54264# 0.13583f
C787 a_2228_20424# a_8108_20560# 0.34742f
C788 a_3428_20424# a_4508_20560# 0.04931f
C789 a_52508_12400# a_54908_12400# 0.04266f
C790 comp_done a_34108_37600# 0.03012f
C791 a_43828_54264# a_37028_54264# 26.1538f
C792 comp_out_p a_2908_29600# 1.67882f
C793 a_9308_6160# a_11708_6160# 1.03812f
C794 a_33308_6800# a_34508_6800# 1.00709f
C795 a_51708_50400# a_50628_54264# 0.81019f
C796 a_16228_15624# a_35308_29600# 0.01824f
C797 dac_in[6] a_33308_19200# 0.06079f
C798 a_11308_33600# a_12508_33600# 0.76551f
C799 dout[5] a_41308_33600# 0.03674f
C800 a_33308_19200# a_50628_54264# 0.12595f
C801 a_42508_33600# a_43708_33600# 0.76551f
C802 sample_en a_43708_37600# 0.0288f
C803 a_15028_15624# a_20908_15760# 0.34742f
C804 a_16228_15624# a_17308_15760# 0.04931f
C805 dout[4] a_49708_37600# 0.02765f
C806 a_15028_6024# a_16228_6024# 0.03237f
C807 a_43708_50400# a_44908_50400# 0.42392f
C808 comp_done a_2908_54400# 0.01827f
C809 a_43828_54264# a_3028_54264# 0.13583f
C810 dout[5] a_23428_54264# 0.12915f
C811 comp_done dac_in[6] 0.13166f
C812 a_9828_54264# dout[1] 3.41259f
C813 dout[5] dout[7] 0.26362f
C814 a_11708_10960# a_9308_10960# 1.03812f
C815 a_17308_6160# a_18508_6160# 1.81793f
C816 a_33308_24800# a_43828_54264# 0.32562f
C817 comp_done a_50628_54264# 0.13009f
C818 a_33308_12400# a_35708_12400# 0.04266f
C819 dout[1] a_37028_54264# 0.12238f
C820 dout[3] a_17308_46000# 0.0612f
C821 comp_out_p a_4508_15760# 0.02401f
C822 dout[0] a_20908_46000# 0.12835f
C823 a_52508_12400# a_53708_12400# 1.00702f
C824 a_3428_20424# a_2108_20560# 0.02521f
C825 a_3028_54264# a_5494_49200# 0.03268f
C826 a_2228_20424# a_4508_20560# 0.24111f
C827 a_22108_10960# a_22294_9600# 0.03324f
C828 comp_out_p a_16628_54264# 0.81028f
C829 a_10628_6024# a_11708_6160# 0.04888f
C830 a_2228_10824# a_8108_10960# 0.34742f
C831 a_3428_10824# a_4508_10960# 0.04931f
C832 dac_in[3] dac_in[5] 0.06149f
C833 a_33428_6664# a_34508_6800# 0.0395f
C834 a_15028_15624# a_35308_29600# 0.0232f
C835 a_42908_19200# a_33308_24800# 0.0148f
C836 dac_in[5] a_35308_29600# 0.26776f
C837 a_10108_33600# a_12508_33600# 0.99858f
C838 comp_out_p a_10108_41600# 0.12837f
C839 dout[1] a_3028_54264# 0.49613f
C840 a_41308_33600# a_43708_33600# 0.99858f
C841 dout[5] a_34108_33600# 0.09997f
C842 sample_en a_42508_37600# 0.0229f
C843 a_2108_10960# a_33308_19200# 0.02806f
C844 dac_in[1] a_12294_53200# 0.03268f
C845 a_44228_15064# a_45428_15064# 0.90775f
C846 dout[1] a_33308_24800# 0.24315f
C847 a_15028_15624# a_17308_15760# 0.24111f
C848 a_9828_54264# a_33308_19200# 0.12835f
C849 a_16228_15624# a_14908_15760# 0.02521f
C850 a_34108_41600# a_35308_29600# 0.11376f
C851 dout[1] a_17708_50400# 0.01884f
C852 a_33308_19200# a_37028_54264# 0.12595f
C853 a_11708_10960# a_10628_10824# 0.04888f
C854 a_2908_54400# a_4108_54400# 0.42392f
C855 a_17308_6160# a_16108_6160# 0.2837f
C856 a_33308_12400# a_34508_12400# 1.00709f
C857 comp_out_p a_2108_15760# 0.03507f
C858 a_9828_54264# comp_done 0.12835f
C859 dout[1] a_18508_37600# 0.05997f
C860 a_52628_15064# a_53828_15064# 0.90778f
C861 a_2228_20424# a_2108_20560# 3.2367f
C862 sample_en a_35894_23600# 0.0201f
C863 dout[0] a_43828_54264# 0.1156f
C864 comp_done a_37028_54264# 0.12157f
C865 comp_out_p a_50508_54400# 0.01905f
C866 a_19708_29600# a_18508_29600# 0.76551f
C867 a_14908_6160# a_20908_6160# 0.29742f
C868 a_15028_6024# a_22108_6160# 0.07546f
C869 a_8108_6160# a_11708_6160# 0.04749f
C870 a_33308_19200# a_3028_54264# 0.12734f
C871 a_3428_10824# a_2108_10960# 0.02521f
C872 a_33428_6664# a_33308_6800# 0.958f
C873 a_2228_10824# a_4508_10960# 0.24111f
C874 a_14908_10960# a_35308_29600# 0.01927f
C875 a_11308_46000# a_12508_46000# 1.00762f
C876 dac_in[6] a_47028_19064# 0.28434f
C877 a_33308_19200# a_33308_24800# 21.2876f
C878 a_33308_1200# a_34508_1200# 1.00709f
C879 done a_16628_54264# 0.12157f
C880 a_10108_33600# a_11308_33600# 0.42399f
C881 comp_out_p a_7708_41600# 0.49397f
C882 dout[0] a_5494_49200# 0.012f
C883 a_41308_33600# a_42508_33600# 0.42399f
C884 sample_en a_41308_37600# 0.02104f
C885 dac_in[5] a_38108_54400# 0.80903f
C886 a_47028_19064# a_50628_54264# 0.1934f
C887 dout[1] a_16508_50400# 0.0185f
C888 a_15028_15624# a_14908_15760# 3.2367f
C889 comp_done a_3028_54264# 0.1799f
C890 dac_in[4] a_23428_54264# 0.13593f
C891 dout[6] dac_in[5] 0.23474f
C892 dout[7] dac_in[4] 0.06119f
C893 a_22108_10960# a_15028_10824# 0.07546f
C894 comp_done a_33308_24800# 0.56495f
C895 a_11708_10960# a_8108_10960# 0.04749f
C896 dac_in[7] comp_out_p 0.54414f
C897 dout[0] dout[1] 31.7378f
C898 dac_in[6] dout[2] 0.05879f
C899 a_3028_54264# a_4108_50400# 0.80903f
C900 comp_done a_2908_50400# 0.01827f
C901 comp_out_p a_30228_54264# 1.10652f
C902 dout[6] a_50908_37600# 1.09035f
C903 a_33428_12264# a_34508_12400# 0.0395f
C904 dout[1] a_17308_37600# 0.13845f
C905 comp_out_p a_3428_15624# 0.02118f
C906 dout[4] a_50508_50400# 0.01851f
C907 dout[2] a_50628_54264# 0.12065f
C908 a_2228_20424# a_3428_20424# 0.03237f
C909 sample_en a_40908_24800# 0.0275f
C910 dac_in[0] a_16628_54264# 0.12915f
C911 a_2908_50400# a_4108_50400# 0.42392f
C912 a_19708_29600# a_17308_29600# 0.99858f
C913 a_8108_6160# a_5708_6160# 0.46956f
C914 comp_out_p a_35494_32400# 0.06392f
C915 a_10108_41600# a_12508_41600# 0.99858f
C916 a_7708_41600# a_17308_41600# 1.00186f
C917 a_14908_6160# a_17308_6160# 1.27786f
C918 a_16228_10824# a_35308_29600# 0.01824f
C919 comp_out_p a_4108_41600# 1.73113f
C920 a_2228_10824# a_2108_10960# 3.2367f
C921 a_53828_3864# a_55028_3864# 0.90775f
C922 dout[2] a_19708_37600# 1.09035f
C923 done a_50508_54400# 0.02312f
C924 comp_out_p a_2908_41600# 0.32105f
C925 a_2908_33600# a_11308_33600# 0.04546f
C926 a_34108_33600# a_42508_33600# 0.04546f
C927 sample_en a_34108_37600# 0.02298f
C928 a_15028_15624# a_16228_15624# 0.03237f
C929 a_9828_54264# a_47028_19064# 0.12835f
C930 dout[0] a_33308_19200# 0.12734f
C931 a_47028_19064# a_37028_54264# 0.13435f
C932 a_5708_10960# a_8108_10960# 0.46956f
C933 a_3028_54264# a_4108_54400# 0.06294f
C934 a_23428_6024# a_22108_6160# 0.26027f
C935 a_16508_54400# a_16628_54264# 1.03164f
C936 a_33308_24800# a_38908_41600# 0.06767f
C937 a_33428_12264# a_33308_12400# 0.958f
C938 dout[1] a_12508_37600# 0.03546f
C939 dout[6] a_49708_37600# 1.03879f
C940 comp_out_p a_2228_15624# 0.04802f
C941 a_10908_54400# a_12294_53200# 0.0129f
C942 a_51428_15064# a_52628_15064# 0.90775f
C943 done dac_in[7] 0.06756f
C944 a_9828_54264# dout[2] 0.12675f
C945 sample_en dac_in[6] 1.29374f
C946 a_38108_54400# a_39494_53200# 0.0129f
C947 dout[7] a_23428_54264# 0.12915f
C948 sample_en a_39708_24800# 0.02869f
C949 comp_done dout[0] 0.17797f
C950 done a_30228_54264# 0.27292f
C951 sample_en a_50628_54264# 0.35747f
C952 a_47028_19064# a_3028_54264# 0.12157f
C953 a_15028_6024# a_20908_6160# 0.34742f
C954 a_2908_46000# a_5308_46000# 0.04266f
C955 dout[2] a_37028_54264# 0.12238f
C956 a_10108_41600# a_11308_41600# 0.42399f
C957 a_4508_6160# a_5708_6160# 1.81793f
C958 a_16228_6024# a_17308_6160# 0.04931f
C959 comp_out_p a_20908_46000# 1.69239f
C960 a_15028_10824# a_35308_29600# 0.0232f
C961 dout[0] a_4108_50400# 0.07275f
C962 a_32694_49200# a_30228_54264# 0.03268f
C963 a_47028_19064# a_33308_24800# 0.34115f
C964 a_2908_33600# a_10108_33600# 1.00249f
C965 a_14908_10960# a_20908_10960# 0.29742f
C966 a_34108_33600# a_41308_33600# 1.00249f
C967 a_14908_46000# a_17308_46000# 0.04266f
C968 dout[3] a_16628_54264# 0.18645f
C969 a_10628_6024# a_9308_6160# 0.26027f
C970 dac_in[7] dac_in[0] 0.06119f
C971 dout[2] a_3028_54264# 0.12915f
C972 dout[3] a_10108_41600# 0.03674f
C973 dac_in[6] dac_in[1] 0.06032f
C974 dac_in[0] a_30228_54264# 0.12915f
C975 a_5708_10960# a_4508_10960# 1.81793f
C976 a_20908_6160# a_22108_6160# 2.73702f
C977 a_22294_9600# a_20908_10960# 0.05987f
C978 dac_in[1] a_50628_54264# 0.12656f
C979 dout[2] a_33308_24800# 0.24682f
C980 a_33308_24800# a_43708_50400# 0.02638f
C981 dout[1] a_11308_37600# 0.04175f
C982 dout[6] a_48508_37600# 0.03674f
C983 dout[2] a_17708_50400# 0.06426f
C984 sample_en a_35708_24800# 0.93103f
C985 dout[0] a_4108_54400# 0.02844f
C986 a_4508_6160# a_3308_6160# 0.2837f
C987 a_15028_6024# a_17308_6160# 0.24111f
C988 a_2108_6160# a_5708_6160# 0.4841f
C989 dout[2] a_18508_37600# 1.03879f
C990 a_9828_54264# sample_en 0.2567f
C991 dac_in[6] a_43708_54400# 0.99858f
C992 a_38108_50400# a_37028_54264# 0.81019f
C993 comp_out_p a_19708_46000# 0.01977f
C994 a_52628_3864# a_53828_3864# 0.90778f
C995 a_47028_19064# a_51094_28400# 0.01077f
C996 a_9828_54264# a_9708_54400# 1.01064f
C997 a_51708_54400# a_50628_54264# 0.04466f
C998 comp_out_p a_43828_54264# 1.20696f
C999 sample_en a_37028_54264# 1.81629f
C1000 comp_done a_2908_46000# 0.96866f
C1001 done a_20908_46000# 0.13245f
C1002 a_14908_10960# a_17308_10960# 1.27786f
C1003 a_14908_46000# a_16108_46000# 1.00702f
C1004 a_6508_46000# a_4108_46000# 0.04266f
C1005 a_8108_6160# a_9308_6160# 2.73702f
C1006 dout[0] a_47028_19064# 0.12835f
C1007 rst_latch a_16628_54264# 0.12157f
C1008 a_3308_10960# a_4508_10960# 0.2837f
C1009 dout[3] a_7708_41600# 1.26823f
C1010 a_5708_10960# a_2108_10960# 0.4841f
C1011 a_46508_1200# a_48908_1200# 0.04266f
C1012 a_50908_33600# a_51094_32400# 0.03264f
C1013 a_20908_6160# a_23428_6024# 0.08029f
C1014 a_25894_53200# a_24508_54400# 0.0129f
C1015 a_51708_50400# a_53094_49200# 0.0129f
C1016 a_44908_50400# a_35308_29600# 0.02182f
C1017 dout[2] a_16508_50400# 1.06176f
C1018 a_33308_24800# a_38108_50400# 0.01943f
C1019 dout[1] a_10108_37600# 0.05122f
C1020 dout[6] a_43708_37600# 1.09037f
C1021 sample_en a_3028_54264# 0.24315f
C1022 a_9828_54264# dac_in[1] 3.1619f
C1023 a_50228_15064# a_51428_15064# 0.90778f
C1024 a_3028_54264# a_9708_54400# 0.03856f
C1025 a_35308_41600# a_34108_41600# 0.87222f
C1026 a_49708_37600# a_50908_37600# 0.76551f
C1027 sample_en a_33308_24800# 26.9229f
C1028 dac_in[1] a_37028_54264# 0.12915f
C1029 comp_out_p a_5308_46000# 0.0157f
C1030 a_33308_24800# a_43708_41600# 0.0362f
C1031 dac_in[5] a_39494_53200# 0.03268f
C1032 dac_in[0] a_20908_46000# 0.06079f
C1033 dout[1] comp_out_p 3.84509f
C1034 dac_in[7] dout[3] 0.06119f
C1035 dac_in[6] dout[4] 0.12086f
C1036 dout[0] dout[2] 0.60334f
C1037 dout[2] a_17308_37600# 0.03674f
C1038 dout[3] a_30228_54264# 0.12238f
C1039 a_2108_6160# a_3308_6160# 1.39926f
C1040 a_51094_36400# a_50908_37600# 0.03264f
C1041 a_2908_41600# a_11308_41600# 0.04546f
C1042 dout[6] a_50508_50400# 0.02568f
C1043 dout[4] a_50628_54264# 0.17913f
C1044 dac_in[2] a_16628_54264# 3.20678f
C1045 a_16228_10824# a_17308_10960# 0.04931f
C1046 a_15028_10824# a_20908_10960# 0.34742f
C1047 a_13708_46000# a_16108_46000# 0.04266f
C1048 a_8108_6160# a_10628_6024# 0.08029f
C1049 a_41308_37600# a_35308_29600# 0.03334f
C1050 dac_in[1] a_3028_54264# 0.1475f
C1051 done a_43828_54264# 0.18953f
C1052 a_43708_54400# a_37028_54264# 0.0654f
C1053 dout[3] a_2908_41600# 0.09997f
C1054 a_44108_15200# a_44228_15064# 0.8814f
C1055 comp_out_p a_51708_50400# 0.98755f
C1056 dac_in[1] a_33308_24800# 0.12157f
C1057 a_3308_10960# a_2108_10960# 1.39926f
C1058 a_49708_33600# a_51094_32400# 0.0129f
C1059 a_46508_1200# a_47708_1200# 1.00762f
C1060 dout[6] a_42508_37600# 1.03879f
C1061 comp_out_p a_33308_19200# 1.18496f
C1062 dout[1] a_17308_41600# 0.02299f
C1063 a_48508_37600# a_50908_37600# 0.99858f
C1064 a_33308_24800# a_42508_41600# 0.05964f
C1065 a_4294_40400# a_4108_41600# 0.04392f
C1066 a_51094_36400# a_49708_37600# 0.0129f
C1067 a_17308_29600# a_18508_29600# 0.42399f
C1068 dout[6] a_44908_50400# 0.04652f
C1069 dout[2] a_12508_37600# 1.09037f
C1070 a_43708_29600# a_20908_46000# 0.0312f
C1071 a_3428_6024# a_3308_6160# 1.05947f
C1072 a_2228_6024# a_5708_6160# 0.76262f
C1073 a_51428_3864# a_52628_3864# 0.90775f
C1074 dac_in[0] a_43828_54264# 0.12905f
C1075 a_43708_54400# a_33308_24800# 0.02596f
C1076 done dout[1] 0.12157f
C1077 a_9828_54264# dout[4] 0.12675f
C1078 sample_en dout[0] 0.24993f
C1079 comp_done comp_out_p 16.2821f
C1080 rst_latch dac_in[7] 0.06756f
C1081 comp_out_p a_24508_54400# 0.02782f
C1082 a_15028_10824# a_17308_10960# 0.24111f
C1083 a_16228_10824# a_14908_10960# 0.02521f
C1084 rst_latch a_30228_54264# 0.12595f
C1085 a_16108_15760# a_18508_15760# 0.06606f
C1086 a_10628_15624# a_9308_15760# 0.26027f
C1087 a_34108_37600# a_35308_29600# 0.11376f
C1088 dout[4] a_37028_54264# 0.12238f
C1089 dout[3] a_20908_46000# 0.12886f
C1090 comp_out_p a_4108_50400# 0.01771f
C1091 a_3428_10824# comp_out_p 0.02118f
C1092 a_33308_19200# a_2908_37600# 0.01463f
C1093 dout[5] a_16628_54264# 0.12915f
C1094 a_45308_1200# a_47708_1200# 0.04266f
C1095 dout[6] a_41308_37600# 0.03674f
C1096 dac_in[7] dac_in[2] 0.06119f
C1097 dout[0] dac_in[1] 0.06119f
C1098 dout[1] dac_in[0] 2.36997f
C1099 dout[4] a_3028_54264# 0.12915f
C1100 dac_in[6] dac_in[3] 0.06051f
C1101 a_48508_37600# a_49708_37600# 0.42399f
C1102 dac_in[6] a_35308_29600# 0.05887f
C1103 dac_in[2] a_30228_54264# 0.12915f
C1104 done a_33308_19200# 15.2008f
C1105 a_33308_24800# a_41308_41600# 0.02846f
C1106 dac_in[3] a_50628_54264# 0.12656f
C1107 dout[4] a_33308_24800# 0.44648f
C1108 a_2228_6024# a_3308_6160# 0.25574f
C1109 a_35308_29600# a_50628_54264# 0.12065f
C1110 a_44908_50400# a_46294_49200# 0.0129f
C1111 a_42508_29600# a_20908_46000# 0.0117f
C1112 dout[2] a_11308_37600# 1.03879f
C1113 a_18508_10960# comp_out_p 0.05074f
C1114 comp_done a_49708_29600# 0.0193f
C1115 a_33308_19200# a_32694_49200# 0.01142f
C1116 a_18508_1360# a_20908_1360# 0.06606f
C1117 dac_in[4] a_32694_53200# 0.03268f
C1118 a_24508_1360# a_26908_1360# 1.03812f
C1119 comp_out_p a_38908_41600# 0.39729f
C1120 a_9828_54264# a_10908_54400# 0.06067f
C1121 a_15028_10824# a_14908_10960# 3.2367f
C1122 a_37028_54264# a_36908_50400# 0.99875f
C1123 dout[1] a_10908_50400# 0.06662f
C1124 comp_done done 6.97623f
C1125 dout[3] a_19708_46000# 0.04398f
C1126 a_2228_10824# comp_out_p 0.04802f
C1127 dout[5] a_50508_54400# 0.01789f
C1128 dout[3] a_43828_54264# 0.1156f
C1129 dout[1] a_16508_54400# 0.0185f
C1130 rst_latch a_20908_46000# 0.23145f
C1131 dac_in[0] a_33308_19200# 0.06079f
C1132 a_7708_46000# a_5308_46000# 0.04266f
C1133 a_47028_19064# a_50908_29600# 0.0287f
C1134 comp_done a_48508_41600# 0.03074f
C1135 dout[6] a_34108_37600# 0.09997f
C1136 comp_out_p a_47028_19064# 16.7649f
C1137 a_10908_54400# a_3028_54264# 0.02661f
C1138 a_12508_46000# a_10108_46000# 0.04266f
C1139 a_17708_50400# a_19094_49200# 0.0129f
C1140 a_33308_24800# a_36908_50400# 0.01467f
C1141 a_16108_10960# comp_out_p 0.02485f
C1142 comp_done dac_in[0] 0.06272f
C1143 dout[2] a_10108_37600# 0.03674f
C1144 a_9828_54264# dac_in[3] 0.13507f
C1145 a_50228_3864# a_51428_3864# 0.90778f
C1146 comp_done a_48508_29600# 0.03131f
C1147 a_9828_54264# a_12294_49200# 0.03268f
C1148 a_25828_1224# a_26908_1360# 0.04888f
C1149 a_9828_54264# a_35308_29600# 0.11565f
C1150 dac_in[3] a_37028_54264# 0.12915f
C1151 dac_in[7] dout[5] 0.06493f
C1152 dac_in[6] dout[6] 0.27761f
C1153 dout[1] dout[3] 0.23905f
C1154 comp_out_p dout[2] 2.80026f
C1155 dout[0] dout[4] 0.12255f
C1156 a_15028_10824# a_16228_10824# 0.03237f
C1157 a_37028_54264# a_35308_29600# 0.73756f
C1158 dac_in[2] a_20908_46000# 0.22829f
C1159 dout[5] a_30228_54264# 0.12915f
C1160 comp_out_p a_43708_50400# 0.05216f
C1161 dout[1] a_9708_50400# 1.02698f
C1162 a_2228_6024# a_9308_6160# 0.07546f
C1163 a_2108_6160# a_8108_6160# 0.29742f
C1164 dout[6] a_50628_54264# 0.19628f
C1165 comp_out_p a_5708_20560# 0.08566f
C1166 dac_in[4] a_16628_54264# 0.13593f
C1167 a_59828_3864# a_61028_3864# 0.90066f
C1168 a_43708_33600# a_43894_32400# 0.03264f
C1169 a_47028_19064# a_49708_29600# 0.02848f
C1170 a_6508_46000# a_5308_46000# 1.00702f
C1171 dac_in[3] a_3028_54264# 0.13507f
C1172 rst_latch a_43828_54264# 0.30356f
C1173 a_48508_41600# a_38908_41600# 1.00186f
C1174 a_17308_46000# a_18508_46000# 1.00702f
C1175 a_18508_41600# a_19708_41600# 0.76551f
C1176 a_35308_29600# a_3028_54264# 0.1156f
C1177 dac_in[3] a_33308_24800# 0.13513f
C1178 dout[0] a_18508_33600# 0.05324f
C1179 a_33308_24800# a_35308_29600# 3.57498f
C1180 done a_47028_19064# 8.32143f
C1181 a_11308_46000# a_10108_46000# 1.00702f
C1182 a_43894_36400# a_43708_37600# 0.03264f
C1183 dout[2] a_2908_37600# 0.09997f
C1184 dout[2] a_17308_41600# 0.13354f
C1185 dout[3] a_33308_19200# 0.12835f
C1186 a_59828_9464# a_61028_9464# 0.90066f
C1187 dac_in[0] a_4108_54400# 0.80903f
C1188 a_36908_54400# a_38108_54400# 0.42392f
C1189 a_23308_1360# a_26908_1360# 0.04749f
C1190 a_47028_19064# a_48508_41600# 0.02674f
C1191 comp_out_p a_38108_50400# 0.08383f
C1192 a_2108_6160# a_4508_6160# 1.27786f
C1193 a_37028_54264# a_38108_54400# 0.04143f
C1194 dac_in[2] a_43828_54264# 0.12905f
C1195 rst_latch dout[1] 0.12157f
C1196 comp_done dout[3] 0.12835f
C1197 a_9828_54264# dout[6] 0.12675f
C1198 done dout[2] 0.12341f
C1199 sample_en comp_out_p 2.40575f
C1200 comp_out_p a_3308_20560# 0.02746f
C1201 comp_out_p a_9708_54400# 0.07139f
C1202 a_42508_33600# a_43894_32400# 0.0129f
C1203 dac_in[0] a_47028_19064# 0.06079f
C1204 dout[6] a_37028_54264# 0.12921f
C1205 dout[5] a_20908_46000# 0.16738f
C1206 a_47028_19064# a_48508_29600# 0.02674f
C1207 a_3308_15760# comp_out_p 0.02746f
C1208 a_16108_46000# a_18508_46000# 0.04266f
C1209 a_53708_12400# a_51308_12400# 0.04266f
C1210 dout[0] a_17308_33600# 0.14687f
C1211 a_23428_54264# a_16628_54264# 25.736f
C1212 dout[7] a_16628_54264# 0.12915f
C1213 a_11308_46000# a_8908_46000# 0.04266f
C1214 a_16508_50400# a_35308_29600# 0.0208f
C1215 a_43894_36400# a_42508_37600# 0.0129f
C1216 a_5708_10960# comp_out_p 0.08566f
C1217 a_11308_29600# a_12508_29600# 0.76551f
C1218 a_33308_24800# a_38108_54400# 0.01943f
C1219 a_49028_3864# a_50228_3864# 0.90775f
C1220 dout[2] a_12508_41600# 0.03546f
C1221 dac_in[6] dac_in[5] 25.6611f
C1222 dout[0] dac_in[3] 0.06119f
C1223 dout[1] dac_in[2] 0.06394f
C1224 a_23308_1360# a_20908_1360# 0.46956f
C1225 comp_out_p dac_in[1] 2.44146f
C1226 dac_in[7] dac_in[4] 0.06137f
C1227 dout[6] a_3028_54264# 0.12915f
C1228 dout[2] dac_in[0] 0.05879f
C1229 dac_in[4] a_30228_54264# 3.28845f
C1230 dout[0] a_35308_29600# 1.10468f
C1231 a_47708_6800# a_48908_6800# 1.00702f
C1232 rst_latch a_33308_19200# 0.13526f
C1233 dout[6] a_33308_24800# 0.50537f
C1234 dac_in[5] a_50628_54264# 0.12656f
C1235 a_3428_6024# a_4508_6160# 0.04931f
C1236 comp_out_p a_24508_50400# 1.01975f
C1237 a_2228_6024# a_8108_6160# 0.34742f
C1238 comp_out_p a_42508_41600# 0.02387f
C1239 a_58628_3864# a_59828_3864# 0.90775f
C1240 done sample_en 0.28398f
C1241 comp_done rst_latch 5.57241f
C1242 a_43708_33600# a_20908_46000# 0.03128f
C1243 a_16108_46000# a_17308_46000# 1.00762f
C1244 dout[2] a_16508_54400# 0.05201f
C1245 a_42508_37600# a_43708_37600# 0.76551f
C1246 dout[5] a_43828_54264# 0.18393f
C1247 a_52508_12400# a_51308_12400# 1.00762f
C1248 dout[0] a_12508_33600# 0.03546f
C1249 dout[7] a_50508_54400# 0.01387f
C1250 dac_in[2] a_33308_19200# 0.06756f
C1251 a_3308_10960# comp_out_p 0.02746f
C1252 a_58628_9464# a_59828_9464# 0.90775f
C1253 a_10108_29600# a_12508_29600# 0.99858f
C1254 dout[3] a_47028_19064# 0.12835f
C1255 a_9494_14400# a_8108_15760# 0.05987f
C1256 a_40628_3864# a_41828_3864# 0.90778f
C1257 dout[2] a_11308_41600# 0.04175f
C1258 a_25828_1224# a_24508_1360# 0.26014f
C1259 a_19708_1360# a_20908_1360# 1.81785f
C1260 dac_in[5] a_36908_54400# 0.99858f
C1261 a_46508_6800# a_48908_6800# 0.04266f
C1262 comp_out_p a_23308_50400# 0.07976f
C1263 done dac_in[1] 0.06079f
C1264 sample_en dac_in[0] 0.12157f
C1265 comp_done dac_in[2] 0.06756f
C1266 a_9828_54264# dac_in[5] 0.13515f
C1267 a_3428_6024# a_2108_6160# 0.02521f
C1268 a_2228_6024# a_4508_6160# 0.24111f
C1269 dout[4] a_50908_29600# 1.09035f
C1270 comp_out_p a_41308_41600# 0.0869f
C1271 dac_in[7] dout[7] 0.14152f
C1272 dac_in[5] a_37028_54264# 3.38875f
C1273 dout[1] dout[5] 0.11577f
C1274 dac_in[7] a_23428_54264# 0.13602f
C1275 dout[0] dout[6] 0.11474f
C1276 comp_out_p dout[4] 0.91562f
C1277 dout[2] dout[3] 30.7048f
C1278 dac_in[4] a_20908_46000# 0.06756f
C1279 a_23428_54264# a_30228_54264# 25.736f
C1280 a_37028_54264# a_39494_49200# 0.03268f
C1281 dout[7] a_30228_54264# 0.12915f
C1282 a_42508_33600# a_20908_46000# 0.0117f
C1283 a_33308_19200# a_34108_29600# 0.01826f
C1284 comp_done a_49708_33600# 0.0193f
C1285 a_41308_37600# a_43708_37600# 0.99858f
C1286 dout[0] a_11308_33600# 0.04175f
C1287 a_52508_12400# a_50108_12400# 0.04266f
C1288 a_11708_15760# a_8108_15760# 0.04749f
C1289 a_35494_28400# a_35308_29600# 0.04392f
C1290 dac_in[3] a_25894_53200# 0.03268f
C1291 a_10108_29600# a_11308_29600# 0.42399f
C1292 comp_done a_49708_41600# 0.0193f
C1293 dac_in[5] a_3028_54264# 0.13525f
C1294 dac_in[0] dac_in[1] 25.6599f
C1295 comp_done a_34108_29600# 0.03012f
C1296 a_23308_1360# a_24508_1360# 2.73689f
C1297 a_19708_1360# a_18508_1360# 0.2837f
C1298 dac_in[5] a_33308_24800# 0.28294f
C1299 a_17308_1360# a_20908_1360# 0.4841f
C1300 comp_out_p a_18508_33600# 0.07684f
C1301 dout[5] a_51708_50400# 0.01851f
C1302 a_46508_6800# a_47708_6800# 1.00762f
C1303 rst_latch a_47028_19064# 0.18755f
C1304 a_10628_10824# a_9308_10960# 0.26027f
C1305 a_44908_54400# a_20908_46000# 0.01852f
C1306 a_43894_40400# a_43708_41600# 0.03264f
C1307 a_34108_41600# a_33308_24800# 0.22913f
C1308 a_47028_19064# a_50908_33600# 0.02013f
C1309 dout[5] a_33308_19200# 0.12157f
C1310 dac_in[6] a_46294_53200# 0.03268f
C1311 a_2228_6024# a_2108_6160# 3.2367f
C1312 sample_en a_43708_29600# 0.0288f
C1313 dout[4] a_49708_29600# 1.03879f
C1314 comp_out_p a_36908_50400# 0.09444f
C1315 comp_out_p a_19094_49200# 0.0216f
C1316 a_57428_3864# a_58628_3864# 0.90778f
C1317 a_47028_19064# a_50908_41600# 0.02013f
C1318 comp_out_p a_10908_54400# 0.07763f
C1319 dac_in[4] a_43828_54264# 0.12905f
C1320 comp_done a_48508_33600# 0.03074f
C1321 comp_done dout[5] 0.37164f
C1322 rst_latch dout[2] 0.12341f
C1323 done dout[4] 0.2228f
C1324 a_25894_49200# a_24508_50400# 0.0129f
C1325 sample_en dout[3] 0.2567f
C1326 a_12508_37600# a_12694_36400# 0.03264f
C1327 a_41308_37600# a_42508_37600# 0.42399f
C1328 a_5708_15760# a_8108_15760# 0.46956f
C1329 comp_out_p a_23308_54400# 0.02113f
C1330 dout[0] a_10108_33600# 0.05122f
C1331 dac_in[2] a_47028_19064# 0.06756f
C1332 a_20908_46000# a_23428_54264# 0.13273f
C1333 a_40908_24800# a_42294_23600# 0.0129f
C1334 a_2908_29600# a_11308_29600# 0.04546f
C1335 dout[7] a_20908_46000# 0.16744f
C1336 a_49708_41600# a_38908_41600# 0.04546f
C1337 a_39428_3864# a_40628_3864# 0.90775f
C1338 a_23308_1360# a_25828_1224# 0.08029f
C1339 a_17308_1360# a_18508_1360# 1.39926f
C1340 comp_out_p a_17308_33600# 1.0341f
C1341 a_45308_6800# a_47708_6800# 0.04266f
C1342 a_43894_40400# a_42508_41600# 0.0129f
C1343 a_8108_10960# a_9308_10960# 2.73702f
C1344 a_2228_6024# a_3428_6024# 0.03237f
C1345 sample_en a_42508_29600# 0.02319f
C1346 a_47028_19064# a_49708_33600# 0.01969f
C1347 a_35308_41600# a_33308_24800# 0.01323f
C1348 comp_out_p dac_in[3] 0.38246f
C1349 dout[1] dac_in[4] 0.06119f
C1350 dout[0] dac_in[5] 0.06032f
C1351 dout[3] dac_in[1] 0.06119f
C1352 dout[2] dac_in[2] 0.06921f
C1353 a_44908_54400# a_43828_54264# 0.04423f
C1354 dout[4] dac_in[0] 0.05896f
C1355 comp_out_p a_4508_20560# 0.02401f
C1356 dout[4] a_48508_29600# 0.03674f
C1357 comp_out_p a_35308_29600# 46.619f
C1358 comp_out_p a_12294_49200# 0.01168f
C1359 dout[0] a_17708_54400# 0.03827f
C1360 a_47028_19064# a_49708_41600# 0.01969f
C1361 dout[3] a_24508_50400# 0.0506f
C1362 a_11308_37600# a_12694_36400# 0.0129f
C1363 a_37028_54264# a_46294_53200# 0.02837f
C1364 a_17308_15760# comp_out_p 0.03758f
C1365 a_22294_4800# a_22108_6160# 0.03324f
C1366 a_50508_50400# a_50628_54264# 0.99875f
C1367 a_34108_37600# a_42508_37600# 0.04546f
C1368 a_5708_15760# a_4508_15760# 1.81793f
C1369 sample_en rst_latch 15.1828f
C1370 a_2908_29600# a_10108_29600# 1.00249f
C1371 a_45428_3864# a_46628_3864# 0.90778f
C1372 a_43828_54264# a_23428_54264# 0.1362f
C1373 dout[7] a_43828_54264# 3.51752f
C1374 comp_out_p a_12508_33600# 0.01615f
C1375 a_45308_6800# a_46508_6800# 1.00702f
C1376 a_8108_10960# a_10628_10824# 0.08029f
C1377 dac_in[4] a_33308_19200# 0.10563f
C1378 dout[5] a_47028_19064# 0.31787f
C1379 a_47028_19064# a_48508_33600# 0.02674f
C1380 sample_en a_41308_29600# 0.02104f
C1381 dout[4] a_43708_29600# 1.09037f
C1382 a_49708_29600# a_35308_29600# 0.04546f
C1383 comp_out_p a_2108_20560# 0.03507f
C1384 a_43894_36400# a_33308_24800# 0.01137f
C1385 a_41828_3864# a_43028_3864# 0.90775f
C1386 a_56228_3864# a_57428_3864# 0.90775f
C1387 a_19708_33600# a_19894_32400# 0.03264f
C1388 done dac_in[3] 0.06756f
C1389 rst_latch dac_in[1] 0.06079f
C1390 comp_done dac_in[4] 0.21082f
C1391 dout[3] a_23308_50400# 1.04412f
C1392 sample_en dac_in[2] 0.13513f
C1393 comp_out_p a_38108_54400# 0.08385f
C1394 done a_35308_29600# 0.21643f
C1395 a_14908_15760# comp_out_p 0.06715f
C1396 a_34108_37600# a_41308_37600# 1.00249f
C1397 dout[3] dout[4] 25.7224f
C1398 dout[1] dout[7] 0.1132f
C1399 comp_out_p dout[6] 3.13668f
C1400 dout[1] a_23428_54264# 0.12238f
C1401 dout[2] dout[5] 0.11597f
C1402 a_5708_15760# a_2108_15760# 0.4841f
C1403 a_9828_54264# a_12294_53200# 0.01021f
C1404 dout[5] a_43708_50400# 0.01429f
C1405 a_19894_36400# a_19708_37600# 0.03264f
C1406 a_38228_3864# a_39428_3864# 0.90778f
C1407 a_9494_4800# a_9308_6160# 0.03324f
C1408 a_44108_6800# a_46508_6800# 0.04266f
C1409 dac_in[1] dac_in[2] 25.6599f
C1410 dac_in[0] dac_in[3] 0.06137f
C1411 sample_en a_34108_29600# 0.02298f
C1412 dac_in[0] a_35308_29600# 0.05441f
C1413 a_33308_24800# a_43708_37600# 0.0362f
C1414 a_20908_46000# a_18508_46000# 0.0399f
C1415 a_48508_29600# a_35308_29600# 1.00186f
C1416 dout[7] a_51708_50400# 0.07171f
C1417 dout[4] a_42508_29600# 1.03879f
C1418 comp_out_p a_3428_20424# 0.02118f
C1419 a_33308_19200# a_23428_54264# 0.13273f
C1420 dout[7] a_33308_19200# 0.12157f
C1421 a_16228_15624# comp_out_p 0.01659f
C1422 a_22294_4800# a_20908_6160# 0.05987f
C1423 a_12294_49200# a_10908_50400# 0.0129f
C1424 dout[5] a_38108_50400# 0.04143f
C1425 a_35708_24800# a_35894_23600# 0.042f
C1426 a_33308_24800# a_42294_23600# 0.01226f
C1427 a_39708_24800# a_40908_24800# 0.42392f
C1428 comp_out_p a_4294_36400# 0.08144f
C1429 a_59708_6800# a_60908_6800# 0.96154f
C1430 a_44228_3864# a_45428_3864# 0.90775f
C1431 comp_done a_23428_54264# 0.13273f
C1432 done dout[6] 0.21603f
C1433 rst_latch dout[4] 0.37416f
C1434 a_24508_54400# a_23428_54264# 0.06024f
C1435 comp_done dout[7] 0.37662f
C1436 sample_en dout[5] 0.70269f
C1437 a_11308_46000# comp_out_p 0.035f
C1438 a_35308_29600# a_16508_54400# 0.0208f
C1439 a_17308_1360# a_23308_1360# 0.29742f
C1440 dout[4] a_50908_33600# 0.06896f
C1441 comp_out_p a_10108_33600# 0.07854f
C1442 dout[3] a_23308_54400# 0.03349f
C1443 a_44108_6800# a_45308_6800# 1.00762f
C1444 dac_in[4] a_47028_19064# 0.06756f
C1445 a_33308_19200# a_34108_33600# 0.01826f
C1446 dout[4] a_50908_41600# 0.02564f
C1447 a_33308_24800# a_42508_37600# 0.05968f
C1448 dout[6] a_48508_41600# 0.12446f
C1449 a_19708_46000# a_18508_46000# 1.0077f
C1450 a_2108_15760# a_8108_15760# 0.29742f
C1451 dout[4] a_41308_29600# 0.03674f
C1452 comp_out_p a_2228_20424# 0.04802f
C1453 dout[1] a_19708_33600# 1.09035f
C1454 dout[6] a_51094_40400# 0.01226f
C1455 comp_out_p a_17308_10960# 0.03758f
C1456 comp_done a_34108_33600# 0.03012f
C1457 dout[3] dac_in[3] 0.06119f
C1458 comp_out_p dac_in[5] 0.60279f
C1459 a_8908_46000# a_10108_46000# 1.00762f
C1460 dout[5] dac_in[1] 0.06136f
C1461 dout[2] dac_in[4] 0.06119f
C1462 dout[4] dac_in[2] 0.06119f
C1463 dout[6] dac_in[0] 0.05959f
C1464 a_15028_15624# comp_out_p 0.07551f
C1465 a_12508_33600# a_12694_32400# 0.03264f
C1466 dout[3] a_35308_29600# 0.17775f
C1467 comp_out_p a_17708_54400# 0.03999f
C1468 a_5708_15760# a_2228_15624# 0.76262f
C1469 a_33308_24800# a_35894_23600# 0.01847f
C1470 comp_out_p a_34108_41600# 0.09756f
C1471 a_19894_36400# a_18508_37600# 0.0129f
C1472 a_58508_6800# a_60908_6800# 0.0395f
C1473 sample_en a_43708_33600# 0.0288f
C1474 dac_in[6] a_50628_54264# 0.30097f
C1475 a_37028_3864# a_38228_3864# 0.90775f
C1476 dout[7] a_38908_41600# 1.26823f
C1477 dout[4] a_49708_33600# 0.07933f
C1478 a_17308_1360# a_19708_1360# 1.2778f
C1479 a_42908_6800# a_45308_6800# 0.04266f
C1480 comp_out_p a_2908_33600# 1.86716f
C1481 a_9494_4800# a_8108_6160# 0.05987f
C1482 a_2108_10960# a_8108_10960# 0.29742f
C1483 dout[5] a_51708_54400# 0.01847f
C1484 a_33308_24800# a_41308_37600# 0.03101f
C1485 dout[4] a_49708_41600# 0.02765f
C1486 a_17708_54400# a_19094_53200# 0.0129f
C1487 dout[4] a_34108_29600# 0.09997f
C1488 a_2108_15760# a_4508_15760# 1.27786f
C1489 a_19708_46000# a_17308_46000# 0.04266f
C1490 a_47028_19064# a_23428_54264# 0.13273f
C1491 dout[7] a_47028_19064# 0.3859f
C1492 comp_out_p a_14908_10960# 0.06715f
C1493 a_11308_33600# a_12694_32400# 0.0129f
C1494 done dac_in[5] 0.06079f
C1495 comp_out_p a_49708_37600# 0.04546f
C1496 comp_out_p a_35308_41600# 1.73849f
C1497 a_33308_24800# a_40908_24800# 0.03499f
C1498 sample_en dac_in[4] 0.13513f
C1499 rst_latch dac_in[3] 0.06756f
C1500 rst_latch a_35308_29600# 0.19741f
C1501 a_58508_6800# a_59708_6800# 1.0077f
C1502 a_43028_3864# a_44228_3864# 0.90778f
C1503 sample_en a_42508_33600# 0.0229f
C1504 a_9828_54264# dac_in[6] 0.13525f
C1505 dout[3] dout[6] 0.1151f
C1506 dout[4] dout[5] 31.9942f
C1507 dout[2] a_23428_54264# 0.12238f
C1508 dout[4] a_48508_33600# 0.12639f
C1509 dout[2] dout[7] 0.1132f
C1510 done a_34108_41600# 0.02648f
C1511 done a_50908_37600# 0.0288f
C1512 a_42908_6800# a_44108_6800# 1.00702f
C1513 a_2108_10960# a_4508_10960# 1.27786f
C1514 a_9828_54264# a_50628_54264# 0.1341f
C1515 dout[1] a_17308_46000# 0.0278f
C1516 dac_in[6] a_37028_54264# 0.17989f
C1517 a_33308_24800# a_34108_37600# 0.23055f
C1518 a_12508_46000# dout[3] 0.04109f
C1519 a_2228_15624# a_8108_15760# 0.34742f
C1520 a_3428_15624# a_4508_15760# 0.04931f
C1521 a_37028_54264# a_50628_54264# 0.1349f
C1522 dac_in[7] a_16628_54264# 0.13611f
C1523 dac_in[2] dac_in[3] 25.6599f
C1524 dac_in[1] dac_in[4] 0.06137f
C1525 dac_in[0] dac_in[5] 0.06109f
C1526 a_16628_54264# a_30228_54264# 0.13674f
C1527 dac_in[2] a_35308_29600# 0.06119f
C1528 comp_out_p a_16228_10824# 0.01659f
C1529 a_2908_54400# a_3028_54264# 1.01296f
C1530 a_16108_6160# a_35308_29600# 0.03818f
C1531 dac_in[6] a_3028_54264# 0.13547f
C1532 dac_in[6] a_33308_24800# 0.12595f
C1533 a_33308_24800# a_39708_24800# 0.03191f
C1534 a_3028_54264# a_50628_54264# 0.1341f
C1535 comp_out_p a_19708_41600# 0.01936f
C1536 comp_out_p a_48508_37600# 1.00186f
C1537 a_57308_6800# a_59708_6800# 0.04266f
C1538 a_33308_24800# a_50628_54264# 0.2519f
C1539 sample_en a_41308_33600# 0.02104f
C1540 a_35828_3864# a_37028_3864# 0.90778f
C1541 dout[5] a_36908_50400# 1.0073f
C1542 done a_49708_37600# 0.02273f
C1543 done a_35308_41600# 0.0276f
C1544 dout[4] a_43708_33600# 0.03546f
C1545 a_41708_6800# a_44108_6800# 0.04266f
C1546 a_5494_53200# dac_in[0] 0.03268f
C1547 sample_en a_23428_54264# 0.26545f
C1548 rst_latch dout[6] 0.34999f
C1549 sample_en dout[7] 3.77025f
C1550 a_2108_6160# a_33308_19200# 0.02806f
C1551 a_36908_54400# a_37028_54264# 1.0073f
C1552 a_2908_41600# a_10108_41600# 1.00249f
C1553 dout[7] a_43708_41600# 1.09037f
C1554 a_53828_3864# sample_en 0.12842f
C1555 a_17708_54400# a_16508_54400# 0.42392f
C1556 a_34108_29600# a_35308_29600# 1.58673f
C1557 a_3428_15624# a_2108_15760# 0.02521f
C1558 a_2228_15624# a_4508_15760# 0.24111f
C1559 a_9828_54264# a_37028_54264# 0.1361f
C1560 dac_in[7] a_50508_54400# 0.99858f
C1561 comp_out_p a_15028_10824# 0.07551f
C1562 dout[6] a_50908_41600# 0.07038f
C1563 a_19708_41600# a_17308_41600# 0.99858f
C1564 a_18508_37600# a_19708_37600# 0.76551f
C1565 a_44908_54400# a_43708_54400# 0.42392f
C1566 a_33308_24800# a_35708_24800# 0.48597f
C1567 comp_out_p a_18508_41600# 0.0257f
C1568 a_20908_46000# a_16628_54264# 2.05425f
C1569 a_9828_54264# a_3028_54264# 26.121f
C1570 dout[4] dac_in[4] 0.06119f
C1571 dout[7] dac_in[1] 0.06199f
C1572 dout[5] dac_in[3] 0.06119f
C1573 dout[3] dac_in[5] 0.06032f
C1574 a_33308_24800# a_36908_54400# 0.01467f
C1575 dout[6] dac_in[2] 0.06136f
C1576 a_57308_6800# a_58508_6800# 1.00702f
C1577 dac_in[1] a_23428_54264# 0.12915f
C1578 sample_en a_34108_33600# 0.02298f
C1579 dout[3] a_17708_54400# 0.01279f
C1580 dout[5] a_35308_29600# 1.51928f
C1581 a_51308_6800# a_48908_6800# 0.04266f
C1582 a_9828_54264# a_33308_24800# 0.2567f
C1583 dout[4] a_42508_33600# 0.04175f
C1584 comp_out_p a_35494_36400# 0.08221f
C1585 a_14908_6160# a_35308_29600# 0.02004f
C1586 done a_48508_37600# 0.01843f
C1587 a_37028_54264# a_3028_54264# 0.13593f
C1588 a_41708_6800# a_42908_6800# 1.00762f
C1589 dac_in[6] dout[0] 0.05879f
C1590 a_4108_41600# a_7708_41600# 1.36391f
C1591 a_23428_54264# a_24508_50400# 0.80903f
C1592 dac_in[7] a_30228_54264# 0.13593f
C1593 a_33308_24800# a_37028_54264# 0.74597f
C1594 comp_out_p a_50508_50400# 0.07218f
C1595 dout[0] a_50628_54264# 0.12065f
C1596 a_14908_46000# a_35308_29600# 0.01548f
C1597 a_2908_41600# a_7708_41600# 0.33005f
C1598 a_2228_15624# a_2108_15760# 3.2367f
C1599 a_52628_3864# sample_en 0.07335f
C1600 dout[7] a_42508_41600# 1.03879f
C1601 dout[7] a_51708_54400# 0.0225f
C1602 dout[2] a_18508_46000# 0.04155f
C1603 a_17308_37600# a_19708_37600# 0.99858f
C1604 dout[6] a_49708_41600# 0.0602f
C1605 a_18508_41600# a_17308_41600# 0.42399f
C1606 a_33308_24800# a_3028_54264# 0.24315f
C1607 a_22108_15760# a_24508_15760# 1.03812f
C1608 a_3028_54264# a_2908_50400# 0.99858f
C1609 comp_out_p a_42508_37600# 0.01525f
C1610 a_57308_1200# a_58508_1200# 1.00702f
C1611 a_56228_9464# a_57428_9464# 0.90775f
C1612 a_56108_6800# a_58508_6800# 0.04266f
C1613 a_34628_3864# a_35828_3864# 0.90775f
C1614 a_43828_54264# a_16628_54264# 0.136f
C1615 a_50108_6800# a_48908_6800# 1.00762f
C1616 dout[4] a_41308_33600# 0.05122f
C1617 a_40508_6800# a_42908_6800# 0.04266f
C1618 a_16228_6024# a_35308_29600# 0.02431f
C1619 a_4108_41600# a_2908_41600# 0.87222f
C1620 rst_latch dac_in[5] 0.06079f
C1621 a_23428_54264# a_23308_50400# 0.9987f
C1622 a_33308_19200# a_32694_53200# 0.01142f
C1623 comp_out_p a_44908_50400# 0.98748f
C1624 a_45308_1200# a_46508_1200# 1.00702f
C1625 dout[4] a_23428_54264# 0.12915f
C1626 a_9828_54264# dout[0] 0.12238f
C1627 a_2228_6024# a_33308_19200# 0.02849f
C1628 dout[7] a_41308_41600# 0.03674f
C1629 dout[5] dout[6] 31.3959f
C1630 a_2228_15624# a_3428_15624# 0.03237f
C1631 dout[4] dout[7] 0.2579f
C1632 a_51428_3864# sample_en 0.1799f
C1633 done a_50508_50400# 0.03275f
C1634 dout[0] a_37028_54264# 0.12238f
C1635 dout[2] a_17308_46000# 0.02929f
C1636 dac_in[7] a_20908_46000# 0.06756f
C1637 a_35308_41600# a_35494_40400# 0.04392f
C1638 a_33308_19200# a_2908_29600# 0.01463f
C1639 a_20908_46000# a_30228_54264# 0.13273f
C1640 a_50108_12400# a_51308_12400# 1.00702f
C1641 a_23428_15624# a_24508_15760# 0.04888f
C1642 dout[1] a_16628_54264# 0.15989f
C1643 dac_in[3] dac_in[4] 25.6599f
C1644 dac_in[2] dac_in[5] 0.06127f
C1645 comp_out_p a_41308_37600# 0.06728f
C1646 a_56108_1200# a_58508_1200# 0.04266f
C1647 a_16508_50400# a_17708_50400# 0.42392f
C1648 dac_in[4] a_35308_29600# 0.06119f
C1649 a_56108_6800# a_57308_6800# 1.00762f
C1650 a_12508_46000# a_14908_46000# 0.04266f
C1651 dac_in[2] a_17708_54400# 0.80903f
C1652 a_22294_14400# a_22108_15760# 0.03324f
C1653 a_50108_6800# a_47708_6800# 0.04266f
C1654 a_50508_54400# a_43828_54264# 0.14384f
C1655 dout[0] a_3028_54264# 3.24219f
C1656 a_15028_6024# a_35308_29600# 0.02786f
C1657 a_40508_6800# a_41708_6800# 1.00702f
C1658 dout[0] a_33308_24800# 0.24993f
C1659 dout[3] a_19708_41600# 1.09035f
C1660 dout[0] a_2908_50400# 1.01498f
C1661 dout[0] a_17708_50400# 0.03827f
C1662 a_44108_1200# a_46508_1200# 0.04266f
C1663 rst_latch a_49708_37600# 0.03145f
C1664 a_4108_46000# a_5308_46000# 1.00762f
C1665 a_50228_3864# sample_en 0.07347f
C1666 a_33308_19200# a_16628_54264# 0.12157f
C1667 a_17308_37600# a_18508_37600# 0.42399f
C1668 a_44908_54400# a_35308_29600# 0.01926f
C1669 a_23428_54264# a_23308_54400# 1.03325f
C1670 dac_in[7] a_43828_54264# 0.18438f
C1671 a_50628_54264# a_53094_49200# 0.03268f
C1672 a_48908_12400# a_51308_12400# 0.04266f
C1673 a_20908_15760# a_24508_15760# 0.04749f
C1674 a_43828_54264# a_30228_54264# 0.13663f
C1675 comp_out_p a_10108_46000# 0.09991f
C1676 a_43894_28400# a_33308_24800# 0.01137f
C1677 a_55028_9464# a_56228_9464# 0.90778f
C1678 comp_out_p a_34108_37600# 1.68315f
C1679 a_60908_1200# a_58508_1200# 0.0395f
C1680 a_56108_1200# a_57308_1200# 1.00762f
C1681 a_54908_6800# a_57308_6800# 0.04266f
C1682 a_12508_46000# a_13708_46000# 1.00702f
C1683 comp_done a_16628_54264# 0.12157f
C1684 a_33428_3864# a_34628_3864# 0.90778f
C1685 dout[1] a_7708_41600# 0.01064f
C1686 a_50228_15064# a_49028_15064# 0.90775f
C1687 a_41308_33600# a_35308_29600# 0.07647f
C1688 a_39308_6800# a_41708_6800# 0.04266f
C1689 dout[0] a_16508_50400# 0.02074f
C1690 dout[3] a_18508_41600# 1.03879f
C1691 dout[7] dac_in[3] 0.06136f
C1692 dout[5] dac_in[5] 0.12746f
C1693 dac_in[3] a_23428_54264# 3.29819f
C1694 dout[6] dac_in[4] 0.06119f
C1695 a_44108_1200# a_45308_1200# 1.00762f
C1696 a_35308_29600# a_23428_54264# 0.11997f
C1697 dout[7] a_35308_29600# 0.11817f
C1698 a_33308_19200# a_2108_15760# 0.02806f
C1699 a_49028_3864# sample_en 1.1129f
C1700 rst_latch a_48508_37600# 0.02515f
C1701 comp_out_p a_2908_54400# 0.0238f
C1702 dac_in[7] dout[1] 0.06119f
C1703 dac_in[6] comp_out_p 0.43339f
C1704 dout[5] a_50908_37600# 0.07357f
C1705 dout[1] a_30228_54264# 0.12238f
C1706 dout[0] a_17308_37600# 0.0327f
C1707 comp_out_p a_4508_10960# 0.02401f
C1708 comp_out_p a_50628_54264# 4.33487f
C1709 comp_done a_4108_46000# 0.07784f
C1710 a_18508_33600# a_19708_33600# 0.76551f
C1711 a_48908_12400# a_50108_12400# 1.00762f
C1712 a_3308_15760# a_5708_15760# 0.06606f
C1713 a_20908_15760# a_18508_15760# 0.46956f
C1714 comp_out_p a_8908_46000# 0.0527f
C1715 a_59708_1200# a_58508_1200# 1.0077f
C1716 comp_out_p a_19708_37600# 0.01936f
C1717 a_54908_1200# a_57308_1200# 0.04266f
C1718 a_11308_46000# a_13708_46000# 0.04266f
C1719 a_54908_6800# a_56108_6800# 1.00702f
C1720 rst_latch start 14.46f
C1721 sample_en start 54.0563f
C1722 done start 24.4136f
C1723 comp_done start 35.1471f
C1724 dout[7] start 20.9147f
C1725 dout[6] start 21.1932f
C1726 dout[5] start 22.1542f
C1727 dout[4] start 24.7969f
C1728 dout[3] start 20.662f
C1729 dout[2] start 17.9353f
C1730 comp_out_p start 0.31033p
C1731 dout[1] start 18.9255f
C1732 dout[0] start 49.3837f
C1733 dac_in[7] start 11.1279f
C1734 dac_in[6] start 10.5898f
C1735 dac_in[5] start 12.8232f
C1736 dac_in[4] start 13.0183f
C1737 dac_in[3] start 10.5008f
C1738 dac_in[2] start 10.3929f
C1739 dac_in[1] start 8.85179f
C1740 dac_in[0] start 9.61647f
C1741 a_24694_0# start 0.47947f
C1742 a_10694_0# start 0.57352f
C1743 a_60908_1200# start 0.46919f
C1744 a_59708_1200# start 1.54607f
C1745 a_58508_1200# start 1.42195f
C1746 a_57308_1200# start 1.42952f
C1747 a_56108_1200# start 1.41742f
C1748 a_54908_1200# start 1.42952f
C1749 a_53708_1200# start 1.41742f
C1750 a_52508_1200# start 1.42952f
C1751 a_51308_1200# start 1.41742f
C1752 a_50108_1200# start 1.42952f
C1753 a_48908_1200# start 1.40446f
C1754 a_47708_1200# start 1.42441f
C1755 a_46508_1200# start 1.41742f
C1756 a_45308_1200# start 1.42952f
C1757 a_44108_1200# start 1.41742f
C1758 a_42908_1200# start 1.42952f
C1759 a_41708_1200# start 1.41742f
C1760 a_40508_1200# start 1.42952f
C1761 a_39308_1200# start 1.41742f
C1762 a_38108_1200# start 1.42952f
C1763 a_36908_1200# start 1.41742f
C1764 a_35708_1200# start 1.43359f
C1765 a_34508_1200# start 1.49067f
C1766 a_33308_1200# start 2.54697f
C1767 a_26908_1360# start 0.53934f
C1768 a_20908_1360# start 3.70183f
C1769 a_18508_1360# start 1.34703f
C1770 a_24508_1360# start 3.88788f
C1771 a_25828_1224# start 0.79594f
C1772 a_23308_1360# start 2.79472f
C1773 a_19708_1360# start 2.05539f
C1774 a_17308_1360# start 4.82908f
C1775 a_18628_1224# start 0.74088f
C1776 a_11828_1424# start 1.37077f
C1777 a_3428_1424# start 8.61546f
C1778 a_2228_1424# start 2.0417f
C1779 a_33308_4000# start 0.56138f
C1780 a_61028_3864# start 0.72867f
C1781 a_59828_3864# start 1.41824f
C1782 a_58628_3864# start 1.39403f
C1783 a_57428_3864# start 1.38696f
C1784 a_56228_3864# start 1.39004f
C1785 a_55028_3864# start 1.38696f
C1786 a_53828_3864# start 1.39004f
C1787 a_52628_3864# start 1.38696f
C1788 a_51428_3864# start 1.39004f
C1789 a_50228_3864# start 1.38696f
C1790 a_49028_3864# start 1.38376f
C1791 a_46628_3864# start 1.38933f
C1792 a_45428_3864# start 1.38696f
C1793 a_44228_3864# start 1.39004f
C1794 a_43028_3864# start 1.38696f
C1795 a_41828_3864# start 1.39004f
C1796 a_40628_3864# start 1.38696f
C1797 a_39428_3864# start 1.39004f
C1798 a_38228_3864# start 1.38696f
C1799 a_37028_3864# start 1.39004f
C1800 a_35828_3864# start 1.39022f
C1801 a_34628_3864# start 1.41586f
C1802 a_33428_3864# start 1.46208f
C1803 a_22294_4800# start 0.45292f
C1804 a_9494_4800# start 0.45292f
C1805 a_24508_6160# start 0.51324f
C1806 a_18508_6160# start 2.85f
C1807 a_16108_6160# start 1.04419f
C1808 a_11708_6160# start 0.51324f
C1809 a_5708_6160# start 2.85f
C1810 a_3308_6160# start 1.09966f
C1811 a_22108_6160# start 3.6911f
C1812 a_23428_6024# start 0.77844f
C1813 a_20908_6160# start 2.40038f
C1814 a_17308_6160# start 1.76343f
C1815 a_14908_6160# start 1.54467f
C1816 a_16228_6024# start 0.68624f
C1817 a_15028_6024# start 2.81155f
C1818 a_9308_6160# start 3.68446f
C1819 a_10628_6024# start 0.77844f
C1820 a_8108_6160# start 2.40038f
C1821 a_4508_6160# start 1.77802f
C1822 a_2108_6160# start 1.68728f
C1823 a_3428_6024# start 0.7115f
C1824 a_2228_6024# start 2.9156f
C1825 a_60908_6800# start 0.46288f
C1826 a_59708_6800# start 1.53471f
C1827 a_58508_6800# start 1.41854f
C1828 a_57308_6800# start 1.41764f
C1829 a_56108_6800# start 1.41401f
C1830 a_54908_6800# start 1.41764f
C1831 a_53708_6800# start 1.41401f
C1832 a_52508_6800# start 1.41764f
C1833 a_51308_6800# start 1.41401f
C1834 a_50108_6800# start 1.41764f
C1835 a_48908_6800# start 1.41401f
C1836 a_47708_6800# start 1.41764f
C1837 a_46508_6800# start 1.41401f
C1838 a_45308_6800# start 1.41764f
C1839 a_44108_6800# start 1.41401f
C1840 a_42908_6800# start 1.41764f
C1841 a_41708_6800# start 1.41401f
C1842 a_40508_6800# start 1.41764f
C1843 a_39308_6800# start 1.41401f
C1844 a_38108_6800# start 1.41764f
C1845 a_36908_6800# start 1.41401f
C1846 a_35708_6800# start 1.42171f
C1847 a_34508_6800# start 1.44748f
C1848 a_33308_6800# start 1.58823f
C1849 a_33428_6664# start 0.64575f
C1850 a_33308_9600# start 0.56164f
C1851 a_22294_9600# start 0.45292f
C1852 a_61028_9464# start 0.72861f
C1853 a_59828_9464# start 1.42401f
C1854 a_58628_9464# start 1.39678f
C1855 a_57428_9464# start 1.39273f
C1856 a_56228_9464# start 1.3928f
C1857 a_55028_9464# start 1.39273f
C1858 a_53828_9464# start 1.3928f
C1859 a_52628_9464# start 1.39273f
C1860 a_51428_9464# start 1.3928f
C1861 a_50228_9464# start 1.39273f
C1862 a_49028_9464# start 1.3928f
C1863 a_47828_9464# start 1.39273f
C1864 a_46628_9464# start 1.3928f
C1865 a_45428_9464# start 1.39273f
C1866 a_44228_9464# start 1.3928f
C1867 a_43028_9464# start 1.39273f
C1868 a_41828_9464# start 1.3928f
C1869 a_40628_9464# start 1.39273f
C1870 a_39428_9464# start 1.3928f
C1871 a_38228_9464# start 1.39273f
C1872 a_37028_9464# start 1.3928f
C1873 a_35828_9464# start 1.39598f
C1874 a_34628_9464# start 1.41862f
C1875 a_33428_9464# start 1.46736f
C1876 a_9494_9600# start 0.45292f
C1877 a_24508_10960# start 0.51324f
C1878 a_18508_10960# start 2.85f
C1879 a_16108_10960# start 1.04419f
C1880 a_11708_10960# start 0.51324f
C1881 a_5708_10960# start 2.85f
C1882 a_3308_10960# start 1.09424f
C1883 a_22108_10960# start 3.6911f
C1884 a_23428_10824# start 0.77844f
C1885 a_20908_10960# start 2.40038f
C1886 a_17308_10960# start 1.76343f
C1887 a_14908_10960# start 1.54467f
C1888 a_16228_10824# start 0.69139f
C1889 a_15028_10824# start 2.82959f
C1890 a_9308_10960# start 3.68446f
C1891 a_10628_10824# start 0.77844f
C1892 a_8108_10960# start 2.40038f
C1893 a_4508_10960# start 1.77802f
C1894 a_2108_10960# start 1.67735f
C1895 a_3428_10824# start 0.7096f
C1896 a_2228_10824# start 2.91268f
C1897 a_60908_12400# start 0.46288f
C1898 a_59708_12400# start 1.53471f
C1899 a_58508_12400# start 1.41854f
C1900 a_57308_12400# start 1.41764f
C1901 a_56108_12400# start 1.41401f
C1902 a_54908_12400# start 1.41764f
C1903 a_53708_12400# start 1.41401f
C1904 a_52508_12400# start 1.41764f
C1905 a_51308_12400# start 1.41401f
C1906 a_50108_12400# start 1.41764f
C1907 a_48908_12400# start 1.41401f
C1908 a_47708_12400# start 1.41764f
C1909 a_46508_12400# start 1.41401f
C1910 a_45308_12400# start 1.41764f
C1911 a_44108_12400# start 1.41401f
C1912 a_42908_12400# start 1.41764f
C1913 a_41708_12400# start 1.41465f
C1914 a_40508_12400# start 1.41828f
C1915 a_39308_12400# start 1.41465f
C1916 a_38108_12400# start 1.41828f
C1917 a_36908_12400# start 1.41465f
C1918 a_35708_12400# start 1.42234f
C1919 a_34508_12400# start 1.44812f
C1920 a_33308_12400# start 1.58887f
C1921 a_33428_12264# start 0.64638f
C1922 a_22294_14400# start 0.45292f
C1923 a_9494_14400# start 0.45292f
C1924 a_44108_15200# start 0.4486f
C1925 a_61028_15064# start 0.72909f
C1926 a_59828_15064# start 1.42448f
C1927 a_58628_15064# start 1.39888f
C1928 a_57428_15064# start 1.3932f
C1929 a_56228_15064# start 1.39489f
C1930 a_55028_15064# start 1.3932f
C1931 a_53828_15064# start 1.39489f
C1932 a_52628_15064# start 1.3932f
C1933 a_51428_15064# start 1.39489f
C1934 a_50228_15064# start 1.3932f
C1935 a_49028_15064# start 1.39489f
C1936 a_47828_15064# start 1.3932f
C1937 a_46628_15064# start 1.39489f
C1938 a_45428_15064# start 1.39903f
C1939 a_44228_15064# start 1.40968f
C1940 a_24508_15760# start 0.51324f
C1941 a_18508_15760# start 2.85f
C1942 a_16108_15760# start 1.04419f
C1943 a_11708_15760# start 0.51324f
C1944 a_5708_15760# start 2.85f
C1945 a_3308_15760# start 1.09424f
C1946 a_22108_15760# start 3.6911f
C1947 a_23428_15624# start 0.77844f
C1948 a_20908_15760# start 2.40038f
C1949 a_17308_15760# start 1.76343f
C1950 a_14908_15760# start 1.54467f
C1951 a_16228_15624# start 0.69139f
C1952 a_15028_15624# start 2.82959f
C1953 a_9308_15760# start 3.68446f
C1954 a_10628_15624# start 0.77844f
C1955 a_8108_15760# start 2.40038f
C1956 a_4508_15760# start 1.77802f
C1957 a_2108_15760# start 1.67735f
C1958 a_3428_15624# start 0.7096f
C1959 a_2228_15624# start 2.91268f
C1960 a_43094_18000# start 0.57038f
C1961 a_42908_19200# start 2.02118f
C1962 a_33308_19200# start 40.4294f
C1963 a_9494_19200# start 0.45292f
C1964 a_47028_19064# start 42.707f
C1965 a_11708_20560# start 0.43595f
C1966 a_5708_20560# start 2.85f
C1967 a_3308_20560# start 1.09424f
C1968 a_9308_20560# start 3.69156f
C1969 a_10628_20424# start 0.78287f
C1970 a_8108_20560# start 2.40735f
C1971 a_4508_20560# start 1.77802f
C1972 a_2108_20560# start 1.67735f
C1973 a_3428_20424# start 0.7096f
C1974 a_2228_20424# start 2.91268f
C1975 a_42294_23600# start 0.55342f
C1976 a_35894_23600# start 0.54879f
C1977 a_40908_24800# start 2.54393f
C1978 a_39708_24800# start 1.76908f
C1979 a_35708_24800# start 1.10375f
C1980 a_33308_24800# start 81.8505f
C1981 a_51094_28400# start 0.55293f
C1982 a_43894_28400# start 0.55293f
C1983 a_35494_28400# start 0.58065f
C1984 a_19894_28400# start 0.55293f
C1985 a_12694_28400# start 0.55293f
C1986 a_4294_28400# start 0.58233f
C1987 a_50908_29600# start 1.85264f
C1988 a_49708_29600# start 1.54511f
C1989 a_48508_29600# start 1.70039f
C1990 a_43708_29600# start 1.90207f
C1991 a_42508_29600# start 1.54609f
C1992 a_41308_29600# start 1.72633f
C1993 a_34108_29600# start 5.38837f
C1994 a_19708_29600# start 1.85264f
C1995 a_18508_29600# start 1.54511f
C1996 a_17308_29600# start 1.69613f
C1997 a_12508_29600# start 1.85264f
C1998 a_11308_29600# start 1.54859f
C1999 a_10108_29600# start 1.7192f
C2000 a_2908_29600# start 5.50749f
C2001 a_51094_32400# start 0.55293f
C2002 a_43894_32400# start 0.55293f
C2003 a_35494_32400# start 0.56914f
C2004 a_19894_32400# start 0.55293f
C2005 a_12694_32400# start 0.55293f
C2006 a_4294_32400# start 0.57213f
C2007 a_50908_33600# start 1.80888f
C2008 a_49708_33600# start 1.4866f
C2009 a_48508_33600# start 1.55578f
C2010 a_43708_33600# start 1.85363f
C2011 a_42508_33600# start 1.48864f
C2012 a_41308_33600# start 1.59396f
C2013 a_34108_33600# start 5.40467f
C2014 a_19708_33600# start 1.80888f
C2015 a_18508_33600# start 1.4866f
C2016 a_17308_33600# start 1.55152f
C2017 a_12508_33600# start 1.80413f
C2018 a_11308_33600# start 1.4866f
C2019 a_10108_33600# start 1.58674f
C2020 a_2908_33600# start 5.52456f
C2021 a_51094_36400# start 0.55293f
C2022 a_43894_36400# start 0.55293f
C2023 a_35494_36400# start 0.57727f
C2024 a_19894_36400# start 0.55293f
C2025 a_12694_36400# start 0.55293f
C2026 a_4294_36400# start 0.57444f
C2027 a_50908_37600# start 1.80888f
C2028 a_49708_37600# start 1.4866f
C2029 a_48508_37600# start 1.55578f
C2030 a_43708_37600# start 1.85363f
C2031 a_42508_37600# start 1.48864f
C2032 a_41308_37600# start 1.59396f
C2033 a_34108_37600# start 5.42273f
C2034 a_19708_37600# start 1.80888f
C2035 a_18508_37600# start 1.4866f
C2036 a_17308_37600# start 1.55152f
C2037 a_12508_37600# start 1.80413f
C2038 a_11308_37600# start 1.4866f
C2039 a_10108_37600# start 1.58674f
C2040 a_2908_37600# start 5.54179f
C2041 a_51094_40400# start 0.55293f
C2042 a_43894_40400# start 0.55293f
C2043 a_35494_40400# start 0.57895f
C2044 a_19894_40400# start 0.55293f
C2045 a_12694_40400# start 0.55293f
C2046 a_4294_40400# start 0.57444f
C2047 a_50908_41600# start 1.80888f
C2048 a_49708_41600# start 1.4866f
C2049 a_48508_41600# start 1.55578f
C2050 a_43708_41600# start 1.85363f
C2051 a_42508_41600# start 1.48864f
C2052 a_41308_41600# start 1.59396f
C2053 a_38908_41600# start 4.80085f
C2054 a_34108_41600# start 5.46035f
C2055 a_35308_41600# start 4.06173f
C2056 a_19708_41600# start 1.80888f
C2057 a_18508_41600# start 1.4866f
C2058 a_17308_41600# start 1.55152f
C2059 a_12508_41600# start 1.80413f
C2060 a_11308_41600# start 1.4866f
C2061 a_10108_41600# start 1.58674f
C2062 a_7708_41600# start 4.65661f
C2063 a_2908_41600# start 5.57239f
C2064 a_4108_41600# start 4.0449f
C2065 a_20908_46000# start 40.1407f
C2066 a_19708_46000# start 1.43047f
C2067 a_18508_46000# start 1.42422f
C2068 a_17308_46000# start 1.37111f
C2069 a_16108_46000# start 1.41644f
C2070 a_14908_46000# start 1.37111f
C2071 a_13708_46000# start 1.41984f
C2072 a_12508_46000# start 1.37111f
C2073 a_11308_46000# start 1.41984f
C2074 a_10108_46000# start 1.44564f
C2075 a_8908_46000# start 1.46386f
C2076 a_7708_46000# start 1.43735f
C2077 a_6508_46000# start 1.43637f
C2078 a_5308_46000# start 1.52555f
C2079 a_4108_46000# start 1.52875f
C2080 a_2908_46000# start 1.58428f
C2081 a_53094_49200# start 0.55293f
C2082 a_46294_49200# start 0.57549f
C2083 a_39494_49200# start 0.56343f
C2084 a_32694_49200# start 0.57388f
C2085 a_25894_49200# start 0.55293f
C2086 a_19094_49200# start 0.55293f
C2087 a_12294_49200# start 0.55293f
C2088 a_5494_49200# start 0.57217f
C2089 a_51708_50400# start 1.55542f
C2090 a_50508_50400# start 1.68819f
C2091 a_44908_50400# start 1.63467f
C2092 a_43708_50400# start 1.7316f
C2093 a_38108_50400# start 1.59409f
C2094 a_36908_50400# start 1.72292f
C2095 a_35308_29600# start 65.0896f
C2096 a_24508_50400# start 1.55345f
C2097 a_23308_50400# start 1.68579f
C2098 a_17708_50400# start 1.5543f
C2099 a_16508_50400# start 1.68629f
C2100 a_10908_50400# start 1.55745f
C2101 a_9708_50400# start 1.73362f
C2102 a_4108_50400# start 2.63936f
C2103 a_2908_50400# start 1.87591f
C2104 a_53094_53200# start 0.55342f
C2105 a_46294_53200# start 0.57284f
C2106 a_39494_53200# start 0.56392f
C2107 a_32694_53200# start 0.57525f
C2108 a_25894_53200# start 0.55699f
C2109 a_19094_53200# start 0.56214f
C2110 a_12294_53200# start 0.55504f
C2111 a_5494_53200# start 0.57157f
C2112 a_51708_54400# start 2.54373f
C2113 a_50508_54400# start 1.76821f
C2114 a_50628_54264# start 26.211f
C2115 a_44908_54400# start 2.63707f
C2116 a_43708_54400# start 1.79707f
C2117 a_43828_54264# start 18.9498f
C2118 a_38108_54400# start 2.58032f
C2119 a_36908_54400# start 1.76706f
C2120 a_37028_54264# start 23.5584f
C2121 a_30228_54264# start 24.1963f
C2122 a_24508_54400# start 2.56462f
C2123 a_23308_54400# start 1.76235f
C2124 a_23428_54264# start 18.3052f
C2125 a_17708_54400# start 2.5693f
C2126 a_16508_54400# start 1.73919f
C2127 a_16628_54264# start 15.9597f
C2128 a_10908_54400# start 2.56021f
C2129 a_9708_54400# start 1.79097f
C2130 a_9828_54264# start 16.783f
C2131 a_4108_54400# start 2.63782f
C2132 a_2908_54400# start 1.87541f
C2133 a_3028_54264# start 17.9585f
.ends

.subckt comp_nfet a_n84_0# a_94_0# a_30_760#
X0 a_94_0# a_30_760# a_n84_0# a_94_0# nfet_03v3 ad=4.62p pd=9.64u as=2.135p ps=8.22u w=3.5u l=0.28u
C0 a_30_760# a_n84_0# 0.0235f
C1 a_n84_0# a_94_0# 0.34241f
C2 a_30_760# a_94_0# 0.2399f
.ends

.subckt comp_pfet$3 a_28_n136# a_n92_0# w_n230_n138# VSUBS
X0 w_n230_n138# a_28_n136# a_n92_0# w_n230_n138# pfet_03v3 ad=5.796p pd=11.16u as=2.73p ps=9.7u w=4.2u l=0.28u
C0 w_n230_n138# a_28_n136# 0.17432f
C1 a_n92_0# w_n230_n138# 0.30351f
C2 a_n92_0# a_28_n136# 0.03089f
C3 a_n92_0# VSUBS 0.13713f
C4 a_28_n136# VSUBS 0.0778f
C5 w_n230_n138# VSUBS 2.54362f
.ends

.subckt comp_nfet$6 a_n84_0# a_94_0# a_30_1660#
X0 a_94_0# a_30_1660# a_n84_0# a_94_0# nfet_03v3 ad=10.56p pd=18.64u as=4.88p ps=17.22u w=8u l=0.28u
C0 a_30_1660# a_n84_0# 0.05846f
C1 a_n84_0# a_94_0# 0.83731f
C2 a_30_1660# a_94_0# 0.27303f
.ends

.subckt comp_pfet$1 a_28_900# a_n92_0# w_n230_n138# VSUBS
X0 w_n230_n138# a_28_900# a_n92_0# w_n230_n138# pfet_03v3 ad=5.796p pd=11.16u as=2.73p ps=9.7u w=4.2u l=0.28u
C0 w_n230_n138# a_28_900# 0.17432f
C1 a_n92_0# w_n230_n138# 0.30351f
C2 a_n92_0# a_28_900# 0.03089f
C3 a_n92_0# VSUBS 0.13713f
C4 a_28_900# VSUBS 0.0778f
C5 w_n230_n138# VSUBS 2.54362f
.ends

.subckt comp_nfet$4 a_30_1260# a_n84_0# a_94_0#
X0 a_94_0# a_30_1260# a_n84_0# a_94_0# nfet_03v3 ad=7.92p pd=14.64u as=3.66p ps=13.22u w=6u l=0.28u
C0 a_30_1260# a_n84_0# 0.04298f
C1 a_n84_0# a_94_0# 0.61736f
C2 a_30_1260# a_94_0# 0.25799f
.ends

.subckt comp_nfet$2 a_30_n132# a_n84_0# a_94_0#
X0 a_94_0# a_30_n132# a_n84_0# a_94_0# nfet_03v3 ad=4.62p pd=9.64u as=2.135p ps=8.22u w=3.5u l=0.28u
C0 a_30_n132# a_n84_0# 0.0235f
C1 a_n84_0# a_94_0# 0.34241f
C2 a_30_n132# a_94_0# 0.2399f
.ends

.subckt comp_pfet a_28_n136# a_n92_0# w_n230_n138# VSUBS
X0 w_n230_n138# a_28_n136# a_n92_0# w_n230_n138# pfet_03v3 ad=2.76p pd=6.76u as=1.3p ps=5.3u w=2u l=0.28u
C0 w_n230_n138# a_28_n136# 0.15518f
C1 a_n92_0# w_n230_n138# 0.11176f
C2 a_n92_0# a_28_n136# 0.0115f
C3 a_n92_0# VSUBS 0.06093f
C4 a_28_n136# VSUBS 0.07992f
C5 w_n230_n138# VSUBS 1.54147f
.ends

.subckt comp_pfet$2 a_28_460# a_n92_0# w_n230_n138# VSUBS
X0 w_n230_n138# a_28_460# a_n92_0# w_n230_n138# pfet_03v3 ad=2.76p pd=6.76u as=1.3p ps=5.3u w=2u l=0.28u
C0 w_n230_n138# a_28_460# 0.15518f
C1 a_n92_0# w_n230_n138# 0.11176f
C2 a_n92_0# a_28_460# 0.0115f
C3 a_n92_0# VSUBS 0.06093f
C4 a_28_460# VSUBS 0.07992f
C5 w_n230_n138# VSUBS 1.54147f
.ends

.subckt comp_nfet$5 a_30_n132# a_n84_0# a_94_0#
X0 a_94_0# a_30_n132# a_n84_0# a_94_0# nfet_03v3 ad=7.92p pd=14.64u as=3.66p ps=13.22u w=6u l=0.28u
C0 a_30_n132# a_n84_0# 0.04298f
C1 a_n84_0# a_94_0# 0.61736f
C2 a_30_n132# a_94_0# 0.25799f
.ends

.subckt comp_strongarm_comp_core out_p vin_p vin_n rst_latch out_n vdd vss
Xcomp_nfet_0 out_n vss out_p comp_nfet
Xcomp_pfet$3_0 out_n out_p vdd vss comp_pfet$3
Xcomp_nfet$6_0 vss vss rst_latch comp_nfet$6
Xcomp_pfet$1_0 out_p out_n vdd vss comp_pfet$1
Xcomp_nfet$4_0 vin_p vss vss comp_nfet$4
Xcomp_nfet$2_0 out_n out_p vss comp_nfet$2
Xcomp_pfet_0 rst_latch out_p vdd vss comp_pfet
Xcomp_pfet_1 rst_latch vss vdd vss comp_pfet
Xcomp_pfet$2_0 rst_latch out_n vdd vss comp_pfet$2
Xcomp_pfet$2_1 rst_latch vss vdd vss comp_pfet$2
Xcomp_nfet$5_0 vin_n vss vss comp_nfet$5
C0 out_n out_p 1.74679f
C1 rst_latch vin_p 0.01194f
C2 rst_latch vin_n 0.01048f
C3 rst_latch out_p 0.27629f
C4 rst_latch out_n 0.29061f
C5 out_p vdd 0.91848f
C6 out_n vdd 0.87853f
C7 rst_latch vdd 0.71782f
C8 vdd vss 6.92711f
C9 vin_n vss 0.11539f
C10 out_p vss -0.19167f
C11 out_n vss -0.16122f
C12 vin_p vss 0.1104f
C13 rst_latch vss 1.78684f
.ends

.subckt comp_nfet$9 a_30_380# a_n84_0# a_94_0#
X0 a_94_0# a_30_380# a_n84_0# a_94_0# nfet_03v3 ad=2.112p pd=5.84u as=0.976p ps=4.42u w=1.6u l=0.28u
C0 a_n84_0# a_30_380# 0.01152f
C1 a_n84_0# a_94_0# 0.17965f
C2 a_30_380# a_94_0# 0.23058f
.ends

.subckt comp_pfet$4 a_28_n136# a_n92_0# w_n230_n138# VSUBS
X0 w_n230_n138# a_28_n136# a_n92_0# w_n230_n138# pfet_03v3 ad=5.52p pd=10.76u as=2.6p ps=9.3u w=4u l=0.28u
C0 a_28_n136# a_n92_0# 0.02707f
C1 w_n230_n138# a_n92_0# 0.26489f
C2 a_28_n136# w_n230_n138# 0.17051f
C3 a_n92_0# VSUBS 0.12084f
C4 a_28_n136# VSUBS 0.07793f
C5 w_n230_n138# VSUBS 2.4447f
.ends

.subckt comp_comp_inv_3v3 vi vdd vss vo
Xcomp_nfet$9_0 vi vo vss comp_nfet$9
Xcomp_pfet$4_0 vi vo vdd vss comp_pfet$4
C0 vo vi 0.19481f
C1 vdd vo 0.04209f
C2 vo vss 0.13251f
C3 vdd vss 0.02151f
C4 vi vss -0.0199f
.ends

.subckt comp_pfet$5 a_n92_0# a_28_260# w_n230_n138# VSUBS
X0 w_n230_n138# a_28_260# a_n92_0# w_n230_n138# pfet_03v3 ad=1.38p pd=4.76u as=0.65p ps=3.3u w=1u l=0.28u
C0 a_28_260# w_n230_n138# 0.14751f
C1 a_n92_0# w_n230_n138# 0.0352f
C2 a_n92_0# VSUBS 0.03098f
C3 a_28_260# VSUBS 0.08197f
C4 w_n230_n138# VSUBS 1.08986f
.ends

.subckt comp_nfet$8 a_30_n132# a_n84_0# a_94_0#
X0 a_94_0# a_30_n132# a_n84_0# a_94_0# nfet_03v3 ad=0.66p pd=3.64u as=0.305p ps=2.22u w=0.5u l=0.28u
C0 a_n84_0# a_94_0# 0.07023f
C1 a_30_n132# a_94_0# 0.22571f
.ends

.subckt comp_pfet$1$1 a_28_n136# a_n92_0# w_n230_n138# VSUBS
X0 w_n230_n138# a_28_n136# a_n92_0# w_n230_n138# pfet_03v3 ad=1.38p pd=4.76u as=0.65p ps=3.3u w=1u l=0.28u
C0 a_28_n136# w_n230_n138# 0.14751f
C1 a_n92_0# w_n230_n138# 0.0352f
C2 a_n92_0# VSUBS 0.03098f
C3 a_28_n136# VSUBS 0.08197f
C4 w_n230_n138# VSUBS 1.08986f
.ends

.subckt comp_nfet$3 a_n84_0# a_94_0# a_30_160#
X0 a_94_0# a_30_160# a_n84_0# a_94_0# nfet_03v3 ad=0.66p pd=3.64u as=0.305p ps=2.22u w=0.5u l=0.28u
C0 a_n84_0# a_94_0# 0.07023f
C1 a_30_160# a_94_0# 0.22571f
.ends

.subckt comp_async_nand2 input_A input_B output vdd vss
Xcomp_pfet$5_0 output input_A vdd vss comp_pfet$5
Xcomp_nfet$8_0 input_A output vss comp_nfet$8
Xcomp_pfet$1$1_0 input_B output vdd vss comp_pfet$1$1
Xcomp_nfet$3_0 vss vss input_B comp_nfet$3
C0 output input_B 0.03318f
C1 vdd input_B 0.03147f
C2 output input_A 0.2678f
C3 input_A vdd 0.02894f
C4 output vdd 0.37426f
C5 input_B vss 0.28859f
C6 output vss 0.13393f
C7 input_A vss 0.0526f
C8 vdd vss 0.35673f
.ends

.subckt comp_comp_nand_3v3 b y vdd a vss
Xcomp_async_nand2_0 a b y vdd vss comp_async_nand2
C0 b vss -0.14653f
C1 y vss -0.24916f
C2 a vss -0.14203f
C3 vdd vss -0.42086f
.ends

.subckt comp_comp_xor_fast a b y comp_comp_nand_3v3_3/b comp_comp_nand_3v3_2/b vdd
+ comp_comp_nand_3v3_3/a vss
Xcomp_comp_nand_3v3_1 b comp_comp_nand_3v3_2/b vdd a vss comp_comp_nand_3v3
Xcomp_comp_nand_3v3_2 comp_comp_nand_3v3_2/b comp_comp_nand_3v3_3/b vdd b vss comp_comp_nand_3v3
Xcomp_comp_nand_3v3_3 comp_comp_nand_3v3_3/b y vdd comp_comp_nand_3v3_3/a vss comp_comp_nand_3v3
Xcomp_comp_nand_3v3_0 comp_comp_nand_3v3_2/b comp_comp_nand_3v3_3/a vdd a vss comp_comp_nand_3v3
C0 comp_comp_nand_3v3_3/b comp_comp_nand_3v3_3/a 0.02481f
C1 comp_comp_nand_3v3_3/b b 0.01016f
C2 vdd a 0.32018f
C3 y comp_comp_nand_3v3_3/a 0.02873f
C4 vdd comp_comp_nand_3v3_2/b 0.3953f
C5 y comp_comp_nand_3v3_3/b 0.09745f
C6 a comp_comp_nand_3v3_3/a 0.01214f
C7 comp_comp_nand_3v3_3/a comp_comp_nand_3v3_2/b 0.19722f
C8 a b 0.10918f
C9 comp_comp_nand_3v3_3/b comp_comp_nand_3v3_2/b 0.2078f
C10 b comp_comp_nand_3v3_2/b 0.2062f
C11 vdd comp_comp_nand_3v3_3/a 0.17953f
C12 vdd comp_comp_nand_3v3_3/b 0.06158f
C13 a comp_comp_nand_3v3_2/b 0.13072f
C14 vdd b 0.15822f
C15 vdd y 0.06672f
C16 comp_comp_nand_3v3_3/a vss 0.05417f
C17 a vss 0.45866f
C18 y vss 0.04072f
C19 comp_comp_nand_3v3_3/b vss 0.44242f
C20 b vss 0.75623f
C21 comp_comp_nand_3v3_2/b vss 0.24244f
C22 vdd vss 0.1906f
.ends

.subckt strongarm_comp comp_done out_p out_n vin_p vin_n rst_latch comp_comp_xor_fast_0/comp_comp_nand_3v3_2/b
+ comp_comp_inv_3v3_1/vi comp_comp_xor_fast_0/comp_comp_nand_3v3_3/a comp_comp_inv_3v3_0/vi
+ comp_comp_xor_fast_0/comp_comp_nand_3v3_3/b vdd vss
Xcomp_strongarm_comp_core_0 comp_comp_inv_3v3_1/vi vin_p vin_n rst_latch comp_comp_inv_3v3_0/vi
+ vdd vss comp_strongarm_comp_core
Xcomp_comp_inv_3v3_0 comp_comp_inv_3v3_0/vi vdd vss out_n comp_comp_inv_3v3
Xcomp_comp_inv_3v3_1 comp_comp_inv_3v3_1/vi vdd vss out_p comp_comp_inv_3v3
Xcomp_comp_xor_fast_0 out_p out_n comp_done comp_comp_xor_fast_0/comp_comp_nand_3v3_3/b
+ comp_comp_xor_fast_0/comp_comp_nand_3v3_2/b vdd comp_comp_xor_fast_0/comp_comp_nand_3v3_3/a
+ vss comp_comp_xor_fast
C0 vdd comp_comp_inv_3v3_1/vi 0.44101f
C1 out_n comp_comp_inv_3v3_0/vi 0.02416f
C2 out_p out_n 0.63127f
C3 rst_latch vdd 0.02917f
C4 rst_latch vin_n 0.13866f
C5 comp_comp_xor_fast_0/comp_comp_nand_3v3_2/b out_n 0.01051f
C6 rst_latch comp_comp_inv_3v3_1/vi 0.0777f
C7 vin_p comp_comp_inv_3v3_0/vi 0.01611f
C8 comp_done vdd 0.11749f
C9 out_n vdd 0.56471f
C10 comp_comp_xor_fast_0/comp_comp_nand_3v3_3/a comp_done 0.03205f
C11 vdd comp_comp_inv_3v3_0/vi 0.09109f
C12 vin_n comp_comp_inv_3v3_0/vi 0.05824f
C13 out_p vdd 0.49394f
C14 comp_comp_inv_3v3_0/vi comp_comp_inv_3v3_1/vi 0.18332f
C15 out_p comp_comp_inv_3v3_1/vi 0.05296f
C16 rst_latch comp_comp_inv_3v3_0/vi 0.14396f
C17 vin_p rst_latch 0.14893f
C18 comp_comp_xor_fast_0/comp_comp_nand_3v3_3/a vss -0.70892f
C19 out_p vss -0.95703f
C20 comp_done vss -0.10944f
C21 comp_comp_xor_fast_0/comp_comp_nand_3v3_3/b vss -0.63744f
C22 out_n vss -0.63296f
C23 comp_comp_xor_fast_0/comp_comp_nand_3v3_2/b vss -1.02635f
C24 vdd vss -11.33105f
C25 vin_n vss 0.35979f
C26 comp_comp_inv_3v3_1/vi vss -0.12278f
C27 comp_comp_inv_3v3_0/vi vss 0.70743f
C28 vin_p vss 0.47379f
C29 rst_latch vss -0.61316f
.ends

.subckt cdac_nfet a_254_0# a_30_n132# a_n84_0# a_94_0# a_190_n132#
X0 a_254_0# a_190_n132# a_94_0# a_254_0# nfet_03v3 ad=5.28p pd=10.64u as=1.04p ps=4.52u w=4u l=0.28u
X1 a_94_0# a_30_n132# a_n84_0# a_254_0# nfet_03v3 ad=1.04p pd=4.52u as=2.44p ps=9.22u w=4u l=0.28u
C0 a_94_0# a_30_n132# 0.02942f
C1 a_n84_0# a_94_0# 0.28823f
C2 a_n84_0# a_30_n132# 0.02741f
C3 a_190_n132# a_94_0# 0.02942f
C4 a_190_n132# a_30_n132# 0.0661f
C5 a_94_0# a_254_0# 0.3151f
C6 a_n84_0# a_254_0# 0.1615f
C7 a_190_n132# a_254_0# 0.2076f
C8 a_30_n132# a_254_0# 0.18019f
.ends

.subckt cdac_pfet a_254_0# a_348_860# a_414_0# a_n92_0# a_94_0# a_508_860# a_188_860#
+ a_28_860# w_n230_n138# VSUBS
X0 a_254_0# a_188_860# a_94_0# w_n230_n138# pfet_03v3 ad=1.04p pd=4.52u as=1.04p ps=4.52u w=4u l=0.28u
X1 w_n230_n138# a_508_860# a_414_0# w_n230_n138# pfet_03v3 ad=5.52p pd=10.76u as=1.04p ps=4.52u w=4u l=0.28u
X2 a_94_0# a_28_860# a_n92_0# w_n230_n138# pfet_03v3 ad=1.04p pd=4.52u as=2.6p ps=9.3u w=4u l=0.28u
X3 a_414_0# a_348_860# a_254_0# w_n230_n138# pfet_03v3 ad=1.04p pd=4.52u as=1.04p ps=4.52u w=4u l=0.28u
C0 a_n92_0# w_n230_n138# 0.03964f
C1 a_348_860# w_n230_n138# 0.10299f
C2 a_188_860# a_254_0# 0.02941f
C3 a_94_0# a_254_0# 0.38435f
C4 a_n92_0# a_94_0# 0.27893f
C5 a_188_860# a_348_860# 0.06717f
C6 a_188_860# w_n230_n138# 0.10299f
C7 a_414_0# a_508_860# 0.02941f
C8 a_28_860# a_n92_0# 0.02707f
C9 a_188_860# a_94_0# 0.02941f
C10 a_28_860# w_n230_n138# 0.12037f
C11 a_414_0# a_254_0# 0.38435f
C12 a_508_860# a_348_860# 0.06717f
C13 a_414_0# a_348_860# 0.02941f
C14 a_188_860# a_28_860# 0.06717f
C15 a_28_860# a_94_0# 0.02941f
C16 a_508_860# w_n230_n138# 0.15313f
C17 a_414_0# w_n230_n138# 0.28569f
C18 a_348_860# a_254_0# 0.02941f
C19 a_414_0# VSUBS 0.02011f
C20 a_254_0# VSUBS 0.02011f
C21 a_94_0# VSUBS 0.02011f
C22 a_n92_0# VSUBS 0.12084f
C23 a_508_860# VSUBS 0.05868f
C24 a_348_860# VSUBS 0.04513f
C25 a_188_860# VSUBS 0.04513f
C26 a_28_860# VSUBS 0.06437f
C27 w_n230_n138# VSUBS 4.00118f
.ends

.subckt cdac_nfet$3 a_734_0# a_510_n132# a_254_0# a_894_0# a_670_n132# a_830_n132#
+ a_414_0# a_30_n132# a_n84_0# a_94_0# a_190_n132# a_574_0# a_350_n132#
X0 a_734_0# a_670_n132# a_574_0# a_894_0# nfet_03v3 ad=1.04p pd=4.52u as=1.04p ps=4.52u w=4u l=0.28u
X1 a_254_0# a_190_n132# a_94_0# a_894_0# nfet_03v3 ad=1.04p pd=4.52u as=1.04p ps=4.52u w=4u l=0.28u
X2 a_574_0# a_510_n132# a_414_0# a_894_0# nfet_03v3 ad=1.04p pd=4.52u as=1.04p ps=4.52u w=4u l=0.28u
X3 a_894_0# a_830_n132# a_734_0# a_894_0# nfet_03v3 ad=5.28p pd=10.64u as=1.04p ps=4.52u w=4u l=0.28u
X4 a_94_0# a_30_n132# a_n84_0# a_894_0# nfet_03v3 ad=1.04p pd=4.52u as=2.44p ps=9.22u w=4u l=0.28u
X5 a_414_0# a_350_n132# a_254_0# a_894_0# nfet_03v3 ad=1.04p pd=4.52u as=1.04p ps=4.52u w=4u l=0.28u
C0 a_510_n132# a_414_0# 0.02942f
C1 a_670_n132# a_510_n132# 0.0661f
C2 a_254_0# a_190_n132# 0.02942f
C3 a_254_0# a_414_0# 0.38435f
C4 a_30_n132# a_190_n132# 0.0661f
C5 a_670_n132# a_734_0# 0.02942f
C6 a_350_n132# a_510_n132# 0.0661f
C7 a_190_n132# a_94_0# 0.02942f
C8 a_350_n132# a_190_n132# 0.0661f
C9 a_350_n132# a_414_0# 0.02942f
C10 a_830_n132# a_670_n132# 0.0661f
C11 a_574_0# a_510_n132# 0.02942f
C12 a_254_0# a_94_0# 0.38435f
C13 a_254_0# a_350_n132# 0.02942f
C14 a_30_n132# a_n84_0# 0.02741f
C15 a_830_n132# a_734_0# 0.02942f
C16 a_30_n132# a_94_0# 0.02942f
C17 a_574_0# a_414_0# 0.38435f
C18 a_670_n132# a_574_0# 0.02942f
C19 a_734_0# a_574_0# 0.38435f
C20 a_94_0# a_n84_0# 0.28823f
C21 a_734_0# a_894_0# 0.3151f
C22 a_574_0# a_894_0# 0.02686f
C23 a_414_0# a_894_0# 0.02686f
C24 a_254_0# a_894_0# 0.02686f
C25 a_94_0# a_894_0# 0.02686f
C26 a_n84_0# a_894_0# 0.1615f
C27 a_830_n132# a_894_0# 0.2076f
C28 a_670_n132# a_894_0# 0.14437f
C29 a_510_n132# a_894_0# 0.14437f
C30 a_350_n132# a_894_0# 0.14437f
C31 a_190_n132# a_894_0# 0.14437f
C32 a_30_n132# a_894_0# 0.18019f
.ends

.subckt cdac_pfet$3 a_1054_0# a_734_0# a_254_0# a_894_0# a_348_860# a_828_860# a_988_860#
+ a_414_0# a_n92_0# a_94_0# a_574_0# a_508_860# a_188_860# a_668_860# a_1148_860#
+ a_28_860# w_n230_n138# VSUBS
X0 w_n230_n138# a_1148_860# a_1054_0# w_n230_n138# pfet_03v3 ad=5.52p pd=10.76u as=1.04p ps=4.52u w=4u l=0.28u
X1 a_734_0# a_668_860# a_574_0# w_n230_n138# pfet_03v3 ad=1.04p pd=4.52u as=1.04p ps=4.52u w=4u l=0.28u
X2 a_254_0# a_188_860# a_94_0# w_n230_n138# pfet_03v3 ad=1.04p pd=4.52u as=1.04p ps=4.52u w=4u l=0.28u
X3 a_574_0# a_508_860# a_414_0# w_n230_n138# pfet_03v3 ad=1.04p pd=4.52u as=1.04p ps=4.52u w=4u l=0.28u
X4 a_1054_0# a_988_860# a_894_0# w_n230_n138# pfet_03v3 ad=1.04p pd=4.52u as=1.04p ps=4.52u w=4u l=0.28u
X5 a_894_0# a_828_860# a_734_0# w_n230_n138# pfet_03v3 ad=1.04p pd=4.52u as=1.04p ps=4.52u w=4u l=0.28u
X6 a_94_0# a_28_860# a_n92_0# w_n230_n138# pfet_03v3 ad=1.04p pd=4.52u as=2.6p ps=9.3u w=4u l=0.28u
X7 a_414_0# a_348_860# a_254_0# w_n230_n138# pfet_03v3 ad=1.04p pd=4.52u as=1.04p ps=4.52u w=4u l=0.28u
C0 w_n230_n138# a_n92_0# 0.03964f
C1 a_734_0# a_828_860# 0.02941f
C2 a_1054_0# a_894_0# 0.38435f
C3 a_828_860# a_668_860# 0.06717f
C4 a_254_0# a_414_0# 0.38435f
C5 a_734_0# a_668_860# 0.02941f
C6 a_574_0# a_734_0# 0.38435f
C7 a_574_0# a_668_860# 0.02941f
C8 a_574_0# a_414_0# 0.38435f
C9 a_988_860# a_894_0# 0.02941f
C10 w_n230_n138# a_508_860# 0.10299f
C11 a_254_0# a_188_860# 0.02941f
C12 a_94_0# a_28_860# 0.02941f
C13 w_n230_n138# a_28_860# 0.12037f
C14 a_1054_0# w_n230_n138# 0.28569f
C15 a_348_860# a_508_860# 0.06717f
C16 a_988_860# a_1054_0# 0.02941f
C17 a_988_860# w_n230_n138# 0.10299f
C18 w_n230_n138# a_348_860# 0.10299f
C19 a_894_0# a_828_860# 0.02941f
C20 a_734_0# a_894_0# 0.38435f
C21 a_508_860# a_668_860# 0.06717f
C22 a_1054_0# a_1148_860# 0.02941f
C23 a_574_0# a_508_860# 0.02941f
C24 w_n230_n138# a_1148_860# 0.15313f
C25 a_414_0# a_508_860# 0.02941f
C26 a_254_0# a_94_0# 0.38435f
C27 w_n230_n138# a_828_860# 0.10299f
C28 a_988_860# a_1148_860# 0.06717f
C29 w_n230_n138# a_668_860# 0.10299f
C30 a_988_860# a_828_860# 0.06717f
C31 a_254_0# a_348_860# 0.02941f
C32 a_188_860# a_28_860# 0.06717f
C33 a_414_0# a_348_860# 0.02941f
C34 a_94_0# a_188_860# 0.02941f
C35 w_n230_n138# a_188_860# 0.10299f
C36 a_n92_0# a_28_860# 0.02707f
C37 a_348_860# a_188_860# 0.06717f
C38 a_94_0# a_n92_0# 0.27893f
C39 a_1054_0# VSUBS 0.02011f
C40 a_894_0# VSUBS 0.02011f
C41 a_734_0# VSUBS 0.02011f
C42 a_574_0# VSUBS 0.02011f
C43 a_414_0# VSUBS 0.02011f
C44 a_254_0# VSUBS 0.02011f
C45 a_94_0# VSUBS 0.02011f
C46 a_n92_0# VSUBS 0.12084f
C47 a_1148_860# VSUBS 0.05868f
C48 a_988_860# VSUBS 0.04513f
C49 a_828_860# VSUBS 0.04513f
C50 a_668_860# VSUBS 0.04513f
C51 a_508_860# VSUBS 0.04513f
C52 a_348_860# VSUBS 0.04513f
C53 a_188_860# VSUBS 0.04513f
C54 a_28_860# VSUBS 0.06437f
C55 w_n230_n138# VSUBS 6.0671f
.ends

.subckt cdac_cdac_switch_1b bit_b vdd bot bit vss
Xcdac_nfet_0 vss bit vss bit_b bit cdac_nfet
Xcdac_pfet_0 vdd bit bit_b vdd bit_b bit bit bit vdd vss cdac_pfet
Xcdac_nfet$3_0 bot bit_b vss vss bit_b bit_b bot bit_b vss bot bit_b vss bit_b cdac_nfet$3
Xcdac_pfet$3_0 bot bot vdd vdd bit_b bit_b bit_b bot vdd bot vdd bit_b bit_b bit_b
+ bit_b bit_b vdd vss cdac_pfet$3
C0 vdd bit 0.22529f
C1 bot bit_b 0.70867f
C2 bit bit_b 0.19536f
C3 bit bot 0.0129f
C4 vdd bit_b 0.65186f
C5 vdd bot 0.46186f
C6 vdd vss 5.90196f
C7 bot vss 1.13962f
C8 bit_b vss 0.854f
C9 bit vss 1.18895f
.ends

.subckt cdac_cap_mim m4_n120_n120# m4_0_0# VSUBS
X0 m4_0_0# m4_n120_n120# cap_mim_2f0_m4m5_noshield c_width=5u c_length=5u
C0 m4_n120_n120# m4_0_0# 0.29597f
C1 m4_0_0# VSUBS 0.7709f
C2 m4_n120_n120# VSUBS 0.80036f
.ends

.subckt cdac_8bit vdd vdac dac_in[0] dac_in[7] dac_in[6] dac_in[5] dac_in[4] bot6
+ bot5 bot4 bot3 bot2 bot1 bot0 dac_in[1] dac_in[2] cdac_cdac_switch_1b_1/bit_b bot7
+ cdac_cdac_switch_1b_2/bit_b cdac_cdac_switch_1b_3/bit_b vref dac_in[3] vss
Xcdac_cdac_switch_1b_0 cdac_cdac_switch_1b_0/bit_b vref bot0 dac_in[0] vss cdac_cdac_switch_1b
Xcdac_cdac_switch_1b_1 cdac_cdac_switch_1b_1/bit_b vref bot1 dac_in[1] vss cdac_cdac_switch_1b
Xcdac_cdac_switch_1b_2 cdac_cdac_switch_1b_2/bit_b vref bot2 dac_in[2] vss cdac_cdac_switch_1b
Xcdac_cdac_switch_1b_3 cdac_cdac_switch_1b_3/bit_b vref bot3 dac_in[3] vss cdac_cdac_switch_1b
Xcdac_cdac_switch_1b_4 cdac_cdac_switch_1b_4/bit_b vref bot5 dac_in[5] vss cdac_cdac_switch_1b
Xcdac_cdac_switch_1b_6 cdac_cdac_switch_1b_6/bit_b vref bot6 dac_in[6] vss cdac_cdac_switch_1b
Xcdac_cdac_switch_1b_5 cdac_cdac_switch_1b_5/bit_b vref bot4 dac_in[4] vss cdac_cdac_switch_1b
Xcdac_cap_mim_0[0|0] vdac bot7 vss cdac_cap_mim
Xcdac_cap_mim_0[1|0] vdac bot7 vss cdac_cap_mim
Xcdac_cap_mim_0[2|0] vdac bot7 vss cdac_cap_mim
Xcdac_cap_mim_0[3|0] vdac bot7 vss cdac_cap_mim
Xcdac_cap_mim_0[4|0] vdac bot7 vss cdac_cap_mim
Xcdac_cap_mim_0[5|0] vdac bot7 vss cdac_cap_mim
Xcdac_cap_mim_0[6|0] vdac bot7 vss cdac_cap_mim
Xcdac_cap_mim_0[7|0] vdac bot7 vss cdac_cap_mim
Xcdac_cap_mim_0[8|0] vdac bot7 vss cdac_cap_mim
Xcdac_cap_mim_0[9|0] vdac bot7 vss cdac_cap_mim
Xcdac_cap_mim_0[10|0] vdac bot7 vss cdac_cap_mim
Xcdac_cap_mim_0[11|0] vdac bot7 vss cdac_cap_mim
Xcdac_cap_mim_0[12|0] vdac bot7 vss cdac_cap_mim
Xcdac_cap_mim_0[13|0] vdac bot7 vss cdac_cap_mim
Xcdac_cap_mim_0[14|0] vdac bot7 vss cdac_cap_mim
Xcdac_cap_mim_0[15|0] vdac bot7 vss cdac_cap_mim
Xcdac_cap_mim_0[0|1] vdac bot7 vss cdac_cap_mim
Xcdac_cap_mim_0[1|1] vdac bot7 vss cdac_cap_mim
Xcdac_cap_mim_0[2|1] vdac bot7 vss cdac_cap_mim
Xcdac_cap_mim_0[3|1] vdac bot7 vss cdac_cap_mim
Xcdac_cap_mim_0[4|1] vdac bot7 vss cdac_cap_mim
Xcdac_cap_mim_0[5|1] vdac bot7 vss cdac_cap_mim
Xcdac_cap_mim_0[6|1] vdac bot7 vss cdac_cap_mim
Xcdac_cap_mim_0[7|1] vdac bot7 vss cdac_cap_mim
Xcdac_cap_mim_0[8|1] vdac bot7 vss cdac_cap_mim
Xcdac_cap_mim_0[9|1] vdac bot7 vss cdac_cap_mim
Xcdac_cap_mim_0[10|1] vdac bot7 vss cdac_cap_mim
Xcdac_cap_mim_0[11|1] vdac bot7 vss cdac_cap_mim
Xcdac_cap_mim_0[12|1] vdac bot7 vss cdac_cap_mim
Xcdac_cap_mim_0[13|1] vdac bot7 vss cdac_cap_mim
Xcdac_cap_mim_0[14|1] vdac bot7 vss cdac_cap_mim
Xcdac_cap_mim_0[15|1] vdac bot7 vss cdac_cap_mim
Xcdac_cap_mim_0[0|2] vdac bot7 vss cdac_cap_mim
Xcdac_cap_mim_0[1|2] vdac bot7 vss cdac_cap_mim
Xcdac_cap_mim_0[2|2] vdac bot7 vss cdac_cap_mim
Xcdac_cap_mim_0[3|2] vdac bot7 vss cdac_cap_mim
Xcdac_cap_mim_0[4|2] vdac bot7 vss cdac_cap_mim
Xcdac_cap_mim_0[5|2] vdac bot7 vss cdac_cap_mim
Xcdac_cap_mim_0[6|2] vdac bot7 vss cdac_cap_mim
Xcdac_cap_mim_0[7|2] vdac bot7 vss cdac_cap_mim
Xcdac_cap_mim_0[8|2] vdac bot7 vss cdac_cap_mim
Xcdac_cap_mim_0[9|2] vdac bot7 vss cdac_cap_mim
Xcdac_cap_mim_0[10|2] vdac bot7 vss cdac_cap_mim
Xcdac_cap_mim_0[11|2] vdac bot7 vss cdac_cap_mim
Xcdac_cap_mim_0[12|2] vdac bot7 vss cdac_cap_mim
Xcdac_cap_mim_0[13|2] vdac bot7 vss cdac_cap_mim
Xcdac_cap_mim_0[14|2] vdac bot7 vss cdac_cap_mim
Xcdac_cap_mim_0[15|2] vdac bot7 vss cdac_cap_mim
Xcdac_cap_mim_0[0|3] vdac bot7 vss cdac_cap_mim
Xcdac_cap_mim_0[1|3] vdac bot7 vss cdac_cap_mim
Xcdac_cap_mim_0[2|3] vdac bot7 vss cdac_cap_mim
Xcdac_cap_mim_0[3|3] vdac bot7 vss cdac_cap_mim
Xcdac_cap_mim_0[4|3] vdac bot7 vss cdac_cap_mim
Xcdac_cap_mim_0[5|3] vdac bot7 vss cdac_cap_mim
Xcdac_cap_mim_0[6|3] vdac bot7 vss cdac_cap_mim
Xcdac_cap_mim_0[7|3] vdac bot7 vss cdac_cap_mim
Xcdac_cap_mim_0[8|3] vdac bot7 vss cdac_cap_mim
Xcdac_cap_mim_0[9|3] vdac bot7 vss cdac_cap_mim
Xcdac_cap_mim_0[10|3] vdac bot7 vss cdac_cap_mim
Xcdac_cap_mim_0[11|3] vdac bot7 vss cdac_cap_mim
Xcdac_cap_mim_0[12|3] vdac bot7 vss cdac_cap_mim
Xcdac_cap_mim_0[13|3] vdac bot7 vss cdac_cap_mim
Xcdac_cap_mim_0[14|3] vdac bot7 vss cdac_cap_mim
Xcdac_cap_mim_0[15|3] vdac bot7 vss cdac_cap_mim
Xcdac_cap_mim_0[0|4] vdac bot7 vss cdac_cap_mim
Xcdac_cap_mim_0[1|4] vdac bot7 vss cdac_cap_mim
Xcdac_cap_mim_0[2|4] vdac bot7 vss cdac_cap_mim
Xcdac_cap_mim_0[3|4] vdac bot7 vss cdac_cap_mim
Xcdac_cap_mim_0[4|4] vdac bot7 vss cdac_cap_mim
Xcdac_cap_mim_0[5|4] vdac bot7 vss cdac_cap_mim
Xcdac_cap_mim_0[6|4] vdac bot7 vss cdac_cap_mim
Xcdac_cap_mim_0[7|4] vdac bot7 vss cdac_cap_mim
Xcdac_cap_mim_0[8|4] vdac bot7 vss cdac_cap_mim
Xcdac_cap_mim_0[9|4] vdac bot7 vss cdac_cap_mim
Xcdac_cap_mim_0[10|4] vdac bot7 vss cdac_cap_mim
Xcdac_cap_mim_0[11|4] vdac bot7 vss cdac_cap_mim
Xcdac_cap_mim_0[12|4] vdac bot7 vss cdac_cap_mim
Xcdac_cap_mim_0[13|4] vdac bot7 vss cdac_cap_mim
Xcdac_cap_mim_0[14|4] vdac bot7 vss cdac_cap_mim
Xcdac_cap_mim_0[15|4] vdac bot7 vss cdac_cap_mim
Xcdac_cap_mim_0[0|5] vdac bot7 vss cdac_cap_mim
Xcdac_cap_mim_0[1|5] vdac bot7 vss cdac_cap_mim
Xcdac_cap_mim_0[2|5] vdac bot7 vss cdac_cap_mim
Xcdac_cap_mim_0[3|5] vdac bot7 vss cdac_cap_mim
Xcdac_cap_mim_0[4|5] vdac bot7 vss cdac_cap_mim
Xcdac_cap_mim_0[5|5] vdac bot7 vss cdac_cap_mim
Xcdac_cap_mim_0[6|5] vdac bot7 vss cdac_cap_mim
Xcdac_cap_mim_0[7|5] vdac bot7 vss cdac_cap_mim
Xcdac_cap_mim_0[8|5] vdac bot7 vss cdac_cap_mim
Xcdac_cap_mim_0[9|5] vdac bot7 vss cdac_cap_mim
Xcdac_cap_mim_0[10|5] vdac bot7 vss cdac_cap_mim
Xcdac_cap_mim_0[11|5] vdac bot7 vss cdac_cap_mim
Xcdac_cap_mim_0[12|5] vdac bot7 vss cdac_cap_mim
Xcdac_cap_mim_0[13|5] vdac bot7 vss cdac_cap_mim
Xcdac_cap_mim_0[14|5] vdac bot7 vss cdac_cap_mim
Xcdac_cap_mim_0[15|5] vdac bot7 vss cdac_cap_mim
Xcdac_cap_mim_0[0|6] vdac bot7 vss cdac_cap_mim
Xcdac_cap_mim_0[1|6] vdac bot7 vss cdac_cap_mim
Xcdac_cap_mim_0[2|6] vdac bot7 vss cdac_cap_mim
Xcdac_cap_mim_0[3|6] vdac bot7 vss cdac_cap_mim
Xcdac_cap_mim_0[4|6] vdac bot7 vss cdac_cap_mim
Xcdac_cap_mim_0[5|6] vdac bot7 vss cdac_cap_mim
Xcdac_cap_mim_0[6|6] vdac bot7 vss cdac_cap_mim
Xcdac_cap_mim_0[7|6] vdac bot7 vss cdac_cap_mim
Xcdac_cap_mim_0[8|6] vdac bot7 vss cdac_cap_mim
Xcdac_cap_mim_0[9|6] vdac bot7 vss cdac_cap_mim
Xcdac_cap_mim_0[10|6] vdac bot7 vss cdac_cap_mim
Xcdac_cap_mim_0[11|6] vdac bot7 vss cdac_cap_mim
Xcdac_cap_mim_0[12|6] vdac bot7 vss cdac_cap_mim
Xcdac_cap_mim_0[13|6] vdac bot7 vss cdac_cap_mim
Xcdac_cap_mim_0[14|6] vdac bot7 vss cdac_cap_mim
Xcdac_cap_mim_0[15|6] vdac bot7 vss cdac_cap_mim
Xcdac_cap_mim_0[0|7] vdac bot7 vss cdac_cap_mim
Xcdac_cap_mim_0[1|7] vdac bot7 vss cdac_cap_mim
Xcdac_cap_mim_0[2|7] vdac bot7 vss cdac_cap_mim
Xcdac_cap_mim_0[3|7] vdac bot7 vss cdac_cap_mim
Xcdac_cap_mim_0[4|7] vdac bot7 vss cdac_cap_mim
Xcdac_cap_mim_0[5|7] vdac bot7 vss cdac_cap_mim
Xcdac_cap_mim_0[6|7] vdac bot7 vss cdac_cap_mim
Xcdac_cap_mim_0[7|7] vdac bot7 vss cdac_cap_mim
Xcdac_cap_mim_0[8|7] vdac bot7 vss cdac_cap_mim
Xcdac_cap_mim_0[9|7] vdac bot7 vss cdac_cap_mim
Xcdac_cap_mim_0[10|7] vdac bot7 vss cdac_cap_mim
Xcdac_cap_mim_0[11|7] vdac bot7 vss cdac_cap_mim
Xcdac_cap_mim_0[12|7] vdac bot7 vss cdac_cap_mim
Xcdac_cap_mim_0[13|7] vdac bot7 vss cdac_cap_mim
Xcdac_cap_mim_0[14|7] vdac bot7 vss cdac_cap_mim
Xcdac_cap_mim_0[15|7] vdac bot7 vss cdac_cap_mim
Xcdac_cap_mim_0[0|8] vdac bot6 vss cdac_cap_mim
Xcdac_cap_mim_0[1|8] vdac bot6 vss cdac_cap_mim
Xcdac_cap_mim_0[2|8] vdac bot6 vss cdac_cap_mim
Xcdac_cap_mim_0[3|8] vdac bot6 vss cdac_cap_mim
Xcdac_cap_mim_0[4|8] vdac bot6 vss cdac_cap_mim
Xcdac_cap_mim_0[5|8] vdac bot6 vss cdac_cap_mim
Xcdac_cap_mim_0[6|8] vdac bot6 vss cdac_cap_mim
Xcdac_cap_mim_0[7|8] vdac bot6 vss cdac_cap_mim
Xcdac_cap_mim_0[8|8] vdac bot6 vss cdac_cap_mim
Xcdac_cap_mim_0[9|8] vdac bot6 vss cdac_cap_mim
Xcdac_cap_mim_0[10|8] vdac bot6 vss cdac_cap_mim
Xcdac_cap_mim_0[11|8] vdac bot6 vss cdac_cap_mim
Xcdac_cap_mim_0[12|8] vdac bot6 vss cdac_cap_mim
Xcdac_cap_mim_0[13|8] vdac bot6 vss cdac_cap_mim
Xcdac_cap_mim_0[14|8] vdac bot6 vss cdac_cap_mim
Xcdac_cap_mim_0[15|8] vdac bot6 vss cdac_cap_mim
Xcdac_cap_mim_0[0|9] vdac bot6 vss cdac_cap_mim
Xcdac_cap_mim_0[1|9] vdac bot6 vss cdac_cap_mim
Xcdac_cap_mim_0[2|9] vdac bot6 vss cdac_cap_mim
Xcdac_cap_mim_0[3|9] vdac bot6 vss cdac_cap_mim
Xcdac_cap_mim_0[4|9] vdac bot6 vss cdac_cap_mim
Xcdac_cap_mim_0[5|9] vdac bot6 vss cdac_cap_mim
Xcdac_cap_mim_0[6|9] vdac bot6 vss cdac_cap_mim
Xcdac_cap_mim_0[7|9] vdac bot6 vss cdac_cap_mim
Xcdac_cap_mim_0[8|9] vdac bot6 vss cdac_cap_mim
Xcdac_cap_mim_0[9|9] vdac bot6 vss cdac_cap_mim
Xcdac_cap_mim_0[10|9] vdac bot6 vss cdac_cap_mim
Xcdac_cap_mim_0[11|9] vdac bot6 vss cdac_cap_mim
Xcdac_cap_mim_0[12|9] vdac bot6 vss cdac_cap_mim
Xcdac_cap_mim_0[13|9] vdac bot6 vss cdac_cap_mim
Xcdac_cap_mim_0[14|9] vdac bot6 vss cdac_cap_mim
Xcdac_cap_mim_0[15|9] vdac bot6 vss cdac_cap_mim
Xcdac_cap_mim_0[0|10] vdac bot6 vss cdac_cap_mim
Xcdac_cap_mim_0[1|10] vdac bot6 vss cdac_cap_mim
Xcdac_cap_mim_0[2|10] vdac bot6 vss cdac_cap_mim
Xcdac_cap_mim_0[3|10] vdac bot6 vss cdac_cap_mim
Xcdac_cap_mim_0[4|10] vdac bot6 vss cdac_cap_mim
Xcdac_cap_mim_0[5|10] vdac bot6 vss cdac_cap_mim
Xcdac_cap_mim_0[6|10] vdac bot6 vss cdac_cap_mim
Xcdac_cap_mim_0[7|10] vdac bot6 vss cdac_cap_mim
Xcdac_cap_mim_0[8|10] vdac bot6 vss cdac_cap_mim
Xcdac_cap_mim_0[9|10] vdac bot6 vss cdac_cap_mim
Xcdac_cap_mim_0[10|10] vdac bot6 vss cdac_cap_mim
Xcdac_cap_mim_0[11|10] vdac bot6 vss cdac_cap_mim
Xcdac_cap_mim_0[12|10] vdac bot6 vss cdac_cap_mim
Xcdac_cap_mim_0[13|10] vdac bot6 vss cdac_cap_mim
Xcdac_cap_mim_0[14|10] vdac bot6 vss cdac_cap_mim
Xcdac_cap_mim_0[15|10] vdac bot6 vss cdac_cap_mim
Xcdac_cap_mim_0[0|11] vdac bot6 vss cdac_cap_mim
Xcdac_cap_mim_0[1|11] vdac bot6 vss cdac_cap_mim
Xcdac_cap_mim_0[2|11] vdac bot6 vss cdac_cap_mim
Xcdac_cap_mim_0[3|11] vdac bot6 vss cdac_cap_mim
Xcdac_cap_mim_0[4|11] vdac bot6 vss cdac_cap_mim
Xcdac_cap_mim_0[5|11] vdac bot6 vss cdac_cap_mim
Xcdac_cap_mim_0[6|11] vdac bot6 vss cdac_cap_mim
Xcdac_cap_mim_0[7|11] vdac bot6 vss cdac_cap_mim
Xcdac_cap_mim_0[8|11] vdac bot6 vss cdac_cap_mim
Xcdac_cap_mim_0[9|11] vdac bot6 vss cdac_cap_mim
Xcdac_cap_mim_0[10|11] vdac bot6 vss cdac_cap_mim
Xcdac_cap_mim_0[11|11] vdac bot6 vss cdac_cap_mim
Xcdac_cap_mim_0[12|11] vdac bot6 vss cdac_cap_mim
Xcdac_cap_mim_0[13|11] vdac bot6 vss cdac_cap_mim
Xcdac_cap_mim_0[14|11] vdac bot6 vss cdac_cap_mim
Xcdac_cap_mim_0[15|11] vdac bot6 vss cdac_cap_mim
Xcdac_cap_mim_0[0|12] vdac bot5 vss cdac_cap_mim
Xcdac_cap_mim_0[1|12] vdac bot5 vss cdac_cap_mim
Xcdac_cap_mim_0[2|12] vdac bot5 vss cdac_cap_mim
Xcdac_cap_mim_0[3|12] vdac bot5 vss cdac_cap_mim
Xcdac_cap_mim_0[4|12] vdac bot5 vss cdac_cap_mim
Xcdac_cap_mim_0[5|12] vdac bot5 vss cdac_cap_mim
Xcdac_cap_mim_0[6|12] vdac bot5 vss cdac_cap_mim
Xcdac_cap_mim_0[7|12] vdac bot5 vss cdac_cap_mim
Xcdac_cap_mim_0[8|12] vdac bot5 vss cdac_cap_mim
Xcdac_cap_mim_0[9|12] vdac bot5 vss cdac_cap_mim
Xcdac_cap_mim_0[10|12] vdac bot5 vss cdac_cap_mim
Xcdac_cap_mim_0[11|12] vdac bot5 vss cdac_cap_mim
Xcdac_cap_mim_0[12|12] vdac bot5 vss cdac_cap_mim
Xcdac_cap_mim_0[13|12] vdac bot5 vss cdac_cap_mim
Xcdac_cap_mim_0[14|12] vdac bot5 vss cdac_cap_mim
Xcdac_cap_mim_0[15|12] vdac bot5 vss cdac_cap_mim
Xcdac_cap_mim_0[0|13] vdac bot5 vss cdac_cap_mim
Xcdac_cap_mim_0[1|13] vdac bot5 vss cdac_cap_mim
Xcdac_cap_mim_0[2|13] vdac bot5 vss cdac_cap_mim
Xcdac_cap_mim_0[3|13] vdac bot5 vss cdac_cap_mim
Xcdac_cap_mim_0[4|13] vdac bot5 vss cdac_cap_mim
Xcdac_cap_mim_0[5|13] vdac bot5 vss cdac_cap_mim
Xcdac_cap_mim_0[6|13] vdac bot5 vss cdac_cap_mim
Xcdac_cap_mim_0[7|13] vdac bot5 vss cdac_cap_mim
Xcdac_cap_mim_0[8|13] vdac bot5 vss cdac_cap_mim
Xcdac_cap_mim_0[9|13] vdac bot5 vss cdac_cap_mim
Xcdac_cap_mim_0[10|13] vdac bot5 vss cdac_cap_mim
Xcdac_cap_mim_0[11|13] vdac bot5 vss cdac_cap_mim
Xcdac_cap_mim_0[12|13] vdac bot5 vss cdac_cap_mim
Xcdac_cap_mim_0[13|13] vdac bot5 vss cdac_cap_mim
Xcdac_cap_mim_0[14|13] vdac bot5 vss cdac_cap_mim
Xcdac_cap_mim_0[15|13] vdac bot5 vss cdac_cap_mim
Xcdac_cap_mim_0[0|14] vdac bot4 vss cdac_cap_mim
Xcdac_cap_mim_0[1|14] vdac bot4 vss cdac_cap_mim
Xcdac_cap_mim_0[2|14] vdac bot4 vss cdac_cap_mim
Xcdac_cap_mim_0[3|14] vdac bot4 vss cdac_cap_mim
Xcdac_cap_mim_0[4|14] vdac bot4 vss cdac_cap_mim
Xcdac_cap_mim_0[5|14] vdac bot4 vss cdac_cap_mim
Xcdac_cap_mim_0[6|14] vdac bot4 vss cdac_cap_mim
Xcdac_cap_mim_0[7|14] vdac bot4 vss cdac_cap_mim
Xcdac_cap_mim_0[8|14] vdac bot4 vss cdac_cap_mim
Xcdac_cap_mim_0[9|14] vdac bot4 vss cdac_cap_mim
Xcdac_cap_mim_0[10|14] vdac bot4 vss cdac_cap_mim
Xcdac_cap_mim_0[11|14] vdac bot4 vss cdac_cap_mim
Xcdac_cap_mim_0[12|14] vdac bot4 vss cdac_cap_mim
Xcdac_cap_mim_0[13|14] vdac bot4 vss cdac_cap_mim
Xcdac_cap_mim_0[14|14] vdac bot4 vss cdac_cap_mim
Xcdac_cap_mim_0[15|14] vdac bot4 vss cdac_cap_mim
Xcdac_cap_mim_0[0|15] vdac bot3 vss cdac_cap_mim
Xcdac_cap_mim_0[1|15] vdac bot3 vss cdac_cap_mim
Xcdac_cap_mim_0[2|15] vdac bot3 vss cdac_cap_mim
Xcdac_cap_mim_0[3|15] vdac bot3 vss cdac_cap_mim
Xcdac_cap_mim_0[4|15] vdac bot3 vss cdac_cap_mim
Xcdac_cap_mim_0[5|15] vdac bot3 vss cdac_cap_mim
Xcdac_cap_mim_0[6|15] vdac bot3 vss cdac_cap_mim
Xcdac_cap_mim_0[7|15] vdac bot3 vss cdac_cap_mim
Xcdac_cap_mim_0[8|15] vdac bot2 vss cdac_cap_mim
Xcdac_cap_mim_0[9|15] vdac bot2 vss cdac_cap_mim
Xcdac_cap_mim_0[10|15] vdac bot2 vss cdac_cap_mim
Xcdac_cap_mim_0[11|15] vdac bot2 vss cdac_cap_mim
Xcdac_cap_mim_0[12|15] vdac bot1 vss cdac_cap_mim
Xcdac_cap_mim_0[13|15] vdac bot1 vss cdac_cap_mim
Xcdac_cap_mim_0[14|15] vdac vss vss cdac_cap_mim
Xcdac_cap_mim_0[15|15] vdac bot0 vss cdac_cap_mim
Xcdac_cdac_switch_1b_7 cdac_cdac_switch_1b_7/bit_b vref bot7 dac_in[7] vss cdac_cdac_switch_1b
C0 bot2 bot5 -1.06927f
C1 bot2 bot3 0.07657f
C2 bot4 bot1 -1.15168f
C3 vref dac_in[7] 0.11822f
C4 bot7 bot6 -22.65272f
C5 bot1 vdac 1.95125f
C6 bot4 bot0 0.06629f
C7 vref vdac 0.0864f
C8 bot1 bot5 -0.35642f
C9 dac_in[6] vref 0.11822f
C10 bot2 bot1 0.07657f
C11 bot0 vdac 0.73999f
C12 dac_in[1] vref 0.1115f
C13 bot6 vdac 0.12232p
C14 bot7 vdac 0.25123p
C15 bot6 bot5 2.94808f
C16 bot4 vdac 29.54236f
C17 vref dac_in[3] 0.1115f
C18 dac_in[2] vref 0.11153f
C19 bot4 bot5 2.94808f
C20 vref dac_in[5] 0.1115f
C21 bot3 bot4 -5.1324f
C22 bot2 bot4 -3.60819f
C23 vdac bot5 38.07019f
C24 bot3 vdac 7.82655f
C25 bot3 bot5 -1.78211f
C26 bot2 vdac 3.9296f
C27 dac_in[4] vref 0.11152f
C28 cdac_cdac_switch_1b_7/bit_b vss -1.09134f
C29 dac_in[7] vss 7.08347f
C30 vdac vss 64.52161f
C31 bot5 vss -2.86555f
C32 bot6 vss -19.94818f
C33 bot7 vss -23.15644f
C34 bot4 vss -0.46925f
C35 cdac_cdac_switch_1b_5/bit_b vss -1.07629f
C36 dac_in[4] vss 3.73019f
C37 cdac_cdac_switch_1b_6/bit_b vss -1.07629f
C38 dac_in[6] vss 6.23536f
C39 cdac_cdac_switch_1b_4/bit_b vss -1.07629f
C40 dac_in[5] vss 4.75373f
C41 vref vss 10.06894f
C42 bot3 vss -2.56394f
C43 cdac_cdac_switch_1b_3/bit_b vss -1.07629f
C44 dac_in[3] vss 1.86702f
C45 bot2 vss -1.74071f
C46 cdac_cdac_switch_1b_2/bit_b vss -1.07629f
C47 dac_in[2] vss 1.58821f
C48 bot1 vss -0.94609f
C49 cdac_cdac_switch_1b_1/bit_b vss -1.07476f
C50 dac_in[1] vss 0.84303f
C51 bot0 vss -0.66106f
C52 cdac_cdac_switch_1b_0/bit_b vss -1.07631f
C53 dac_in[0] vss 0.65086f
.ends

.subckt sh_nfet a_30_260# a_n84_0# a_94_0#
X0 a_94_0# a_30_260# a_n84_0# a_94_0# nfet_03v3 ad=1.32p pd=4.64u as=0.61p ps=3.22u w=1u l=0.28u
C0 a_n84_0# a_94_0# 0.06747f
C1 a_30_260# a_94_0# 0.2242f
.ends

.subckt sh_pfet a_28_n136# a_n92_0# w_n230_n138# VSUBS
X0 w_n230_n138# a_28_n136# a_n92_0# w_n230_n138# pfet_03v3 ad=2.76p pd=6.76u as=1.3p ps=5.3u w=2u l=0.28u
C0 a_n92_0# w_n230_n138# 0.11176f
C1 a_28_n136# w_n230_n138# 0.15518f
C2 a_n92_0# a_28_n136# 0.0115f
C3 a_n92_0# VSUBS 0.06093f
C4 a_28_n136# VSUBS 0.07992f
C5 w_n230_n138# VSUBS 1.54147f
.ends

.subckt sh_inv_sh vdd vi vo vss
Xsh_nfet_0 vi vo vss sh_nfet
Xsh_pfet_0 vi vo vdd vss sh_pfet
C0 vi vo 0.25028f
C1 vdd vo 0.07197f
C2 vo vss 0.25534f
C3 vdd vss 0.07135f
C4 vi vss 0.03198f
.ends

.subckt sh_cap_mim m4_n120_n120# m4_0_0# VSUBS
X0 m4_0_0# m4_n120_n120# cap_mim_2f0_m4m5_noshield c_width=15u c_length=10u
C0 m4_n120_n120# m4_0_0# 0.73993f
C1 m4_0_0# VSUBS 2.59242f
C2 m4_n120_n120# VSUBS 1.78179f
.ends

.subckt sh_nfet$2 a_30_n132# a_n84_0# a_94_0#
X0 a_94_0# a_30_n132# a_n84_0# a_94_0# nfet_03v3 ad=5.28p pd=10.64u as=2.44p ps=9.22u w=4u l=0.28u
C0 a_30_n132# a_n84_0# 0.02741f
C1 a_n84_0# a_94_0# 0.3974f
C2 a_30_n132# a_94_0# 0.24343f
.ends

.subckt sh_pfet$2 a_28_n136# a_n92_0# w_n230_n138# VSUBS
X0 w_n230_n138# a_28_n136# a_n92_0# w_n230_n138# pfet_03v3 ad=11.04p pd=18.76u as=5.2p ps=17.3u w=8u l=0.28u
C0 a_n92_0# a_28_n136# 0.05772f
C1 w_n230_n138# a_28_n136# 0.20096f
C2 a_n92_0# w_n230_n138# 0.57114f
C3 a_n92_0# VSUBS 0.24066f
C4 a_28_n136# VSUBS 0.07668f
C5 w_n230_n138# VSUBS 4.25118f
.ends

.subckt sample_hold vdd sample_en clkb vin
Xsh_inv_sh_0 vdd sample_en clkb vin sh_inv_sh
Xsh_cap_mim_0 vdd vin vin sh_cap_mim
Xsh_nfet$2_0 sample_en vdd vin sh_nfet$2
Xsh_pfet$2_0 clkb vin vdd vin sh_pfet$2
C0 vdd clkb 0.27538f
C1 sample_en clkb 0.1653f
C2 vdd sample_en 0.08742f
C3 vdd vin 2.91072f
C4 clkb vin -0.20354f
C5 sample_en vin 0.26362f
.ends

.subckt sar_adc_top vin_p vref done dout[0] dout[1] dout[2] dout[3] dout[4] dout[5]
+ dout[6] dout[7] async_sar_0/a_36908_54400# async_sar_0/a_2908_41600# async_sar_0/a_34108_29600#
+ async_sar_0/a_35308_41600# async_sar_0/a_38108_54400# async_sar_0/a_8108_10960#
+ async_sar_0/a_4108_41600# async_sar_0/a_8108_6160# async_sar_0/a_37028_54264# async_sar_0/a_37028_9464#
+ async_sar_0/a_36908_12400# async_sar_0/a_5708_10960# async_sar_0/a_33308_24800#
+ async_sar_0/a_34108_41600# async_sar_0/a_7708_46000# async_sar_0/a_38108_12400#
+ async_sar_0/a_8108_15760# async_sar_0/a_2908_33600# async_sar_0/a_36908_1200# async_sar_0/a_5708_15760#
+ async_sar_0/a_38108_6800# async_sar_0/a_2228_20424# cdac_8bit_0/dac_in[6] async_sar_0/a_3428_1424#
+ async_sar_0/a_2228_6024# async_sar_0/a_34108_33600# async_sar_0/a_2908_37600# cdac_8bit_0/dac_in[5]
+ async_sar_0/a_38908_41600# async_sar_0/a_7708_41600# cdac_8bit_0/dac_in[0] sample_hold_0/clkb
+ async_sar_0/a_2228_10824# strongarm_comp_0/comp_comp_xor_fast_0/comp_comp_nand_3v3_3/b
+ async_sar_0/a_38228_3864# async_sar_0/a_34108_37600# async_sar_0/a_5708_6160# async_sar_0/a_8108_20560#
+ async_sar_0/a_36908_50400# cdac_8bit_0/dac_in[4] async_sar_0/a_36908_6800# async_sar_0/a_5708_20560#
+ async_sar_0/a_2908_29600# async_sar_0/a_38108_50400# async_sar_0/a_38108_1200# async_sar_0/a_35308_29600#
+ async_sar_0/sample_en async_sar_0/a_37028_3864# dvss async_sar_0/a_38228_9464# async_sar_0/a_2228_15624#
Xasync_sar_0 dvss dvss dvss async_sar_0/sample_en dvss done dout[0] cdac_8bit_0/dac_in[0]
+ dout[1] dvss dout[2] dvss dout[3] dvss dout[4] cdac_8bit_0/dac_in[4] dout[5] cdac_8bit_0/dac_in[5]
+ dout[6] cdac_8bit_0/dac_in[6] dout[7] dvss async_sar_0/a_4108_41600# async_sar_0/a_36908_54400#
+ async_sar_0/a_37028_9464# async_sar_0/a_30228_54264# async_sar_0/a_34108_29600#
+ async_sar_0/a_5708_10960# async_sar_0/a_35308_41600# async_sar_0/a_38108_54400#
+ async_sar_0/a_7708_46000# async_sar_0/a_20908_46000# async_sar_0/a_37028_54264#
+ async_sar_0/a_36908_12400# async_sar_0/a_47028_19064# async_sar_0/a_33308_24800#
+ async_sar_0/a_8108_15760# async_sar_0/a_34108_41600# async_sar_0/a_2908_33600# async_sar_0/a_36908_1200#
+ async_sar_0/a_38108_12400# async_sar_0/a_5708_6160# async_sar_0/a_23428_54264# async_sar_0/a_5708_15760#
+ async_sar_0/a_38108_6800# async_sar_0/a_2228_20424# async_sar_0/a_50628_54264# async_sar_0/a_2908_37600#
+ async_sar_0/sample_en async_sar_0/a_16628_54264# async_sar_0/a_34108_33600# async_sar_0/a_7708_41600#
+ async_sar_0/a_38908_41600# async_sar_0/a_8108_6160# async_sar_0/a_2228_10824# async_sar_0/a_38228_3864#
+ async_sar_0/a_43828_54264# async_sar_0/a_8108_20560# async_sar_0/a_5708_20560# async_sar_0/a_36908_6800#
+ async_sar_0/a_34108_37600# async_sar_0/a_2908_29600# async_sar_0/a_36908_50400#
+ async_sar_0/a_38108_1200# async_sar_0/a_9828_54264# async_sar_0/a_37028_3864# async_sar_0/a_38228_9464#
+ async_sar_0/a_2228_15624# async_sar_0/a_38108_50400# async_sar_0/a_35308_29600#
+ async_sar_0/a_3428_1424# async_sar_0/a_2908_41600# dvss async_sar_0/a_8108_10960#
+ async_sar_0/a_2228_6024# async_sar
Xstrongarm_comp_0 dvss dvss strongarm_comp_0/out_n vref dvss dvss strongarm_comp_0/comp_comp_xor_fast_0/comp_comp_nand_3v3_2/b
+ strongarm_comp_0/comp_comp_inv_3v3_1/vi strongarm_comp_0/comp_comp_xor_fast_0/comp_comp_nand_3v3_3/a
+ strongarm_comp_0/comp_comp_inv_3v3_0/vi strongarm_comp_0/comp_comp_xor_fast_0/comp_comp_nand_3v3_3/b
+ vref dvss strongarm_comp
Xcdac_8bit_0 vref dvss cdac_8bit_0/dac_in[0] dvss cdac_8bit_0/dac_in[6] cdac_8bit_0/dac_in[5]
+ cdac_8bit_0/dac_in[4] cdac_8bit_0/bot6 cdac_8bit_0/bot5 cdac_8bit_0/bot4 cdac_8bit_0/bot3
+ cdac_8bit_0/bot2 cdac_8bit_0/bot1 cdac_8bit_0/bot0 dvss dvss cdac_8bit_0/cdac_cdac_switch_1b_1/bit_b
+ cdac_8bit_0/bot7 cdac_8bit_0/cdac_cdac_switch_1b_2/bit_b cdac_8bit_0/cdac_cdac_switch_1b_3/bit_b
+ vref dvss dvss cdac_8bit
Xsample_hold_0 vref async_sar_0/sample_en sample_hold_0/clkb dvss sample_hold
C0 cdac_8bit_0/dac_in[6] async_sar_0/a_16628_54264# 0.06319f
C1 vref strongarm_comp_0/comp_comp_xor_fast_0/comp_comp_nand_3v3_3/a 0.04417f
C2 async_sar_0/a_43828_54264# async_sar_0/sample_en 0.07025f
C3 async_sar_0/a_50628_54264# cdac_8bit_0/dac_in[0] 0.07208f
C4 vref vin_p 0.04447f
C5 cdac_8bit_0/dac_in[6] async_sar_0/a_9828_54264# 0.06322f
C6 dout[4] async_sar_0/sample_en 0.07696f
C7 cdac_8bit_0/dac_in[4] cdac_8bit_0/dac_in[0] 0.06485f
C8 vref cdac_8bit_0/dac_in[5] 0.9435f
C9 cdac_8bit_0/dac_in[0] async_sar_0/sample_en 0.1351f
C10 async_sar_0/a_16628_54264# cdac_8bit_0/dac_in[4] 0.06316f
C11 async_sar_0/a_43828_54264# cdac_8bit_0/dac_in[5] 0.06316f
C12 async_sar_0/a_9828_54264# cdac_8bit_0/dac_in[4] 0.06316f
C13 async_sar_0/a_16628_54264# async_sar_0/sample_en 0.06551f
C14 async_sar_0/a_47028_19064# async_sar_0/sample_en 0.06751f
C15 async_sar_0/a_9828_54264# async_sar_0/sample_en 0.06551f
C16 cdac_8bit_0/dac_in[0] cdac_8bit_0/dac_in[5] 0.0647f
C17 async_sar_0/a_43828_54264# cdac_8bit_0/dac_in[0] 0.0647f
C18 cdac_8bit_0/dac_in[6] async_sar_0/a_30228_54264# 0.06316f
C19 async_sar_0/a_16628_54264# cdac_8bit_0/dac_in[5] 0.06316f
C20 async_sar_0/a_9828_54264# cdac_8bit_0/dac_in[5] 0.06319f
C21 cdac_8bit_0/dac_in[6] async_sar_0/a_37028_54264# 0.06316f
C22 vref strongarm_comp_0/comp_comp_inv_3v3_1/vi 0.05124f
C23 async_sar_0/a_16628_54264# cdac_8bit_0/dac_in[0] 0.0647f
C24 dout[0] dout[1] 0.12306f
C25 async_sar_0/a_30228_54264# cdac_8bit_0/dac_in[4] 0.06316f
C26 async_sar_0/a_9828_54264# cdac_8bit_0/dac_in[0] 0.0647f
C27 async_sar_0/a_33308_24800# async_sar_0/sample_en 0.13435f
C28 async_sar_0/a_30228_54264# async_sar_0/sample_en 0.06551f
C29 dout[5] async_sar_0/sample_en 0.07696f
C30 async_sar_0/a_37028_54264# cdac_8bit_0/dac_in[4] 0.06316f
C31 async_sar_0/a_37028_54264# async_sar_0/sample_en 0.06789f
C32 cdac_8bit_0/dac_in[6] async_sar_0/a_23428_54264# 0.06316f
C33 dout[1] dout[2] 0.12306f
C34 dout[7] async_sar_0/sample_en 0.07696f
C35 dout[1] async_sar_0/sample_en 0.07696f
C36 async_sar_0/a_30228_54264# cdac_8bit_0/dac_in[5] 0.06316f
C37 dout[6] dout[5] 0.12306f
C38 dout[3] dout[2] 0.12306f
C39 cdac_8bit_0/dac_in[6] async_sar_0/a_50628_54264# 0.07054f
C40 async_sar_0/a_37028_54264# cdac_8bit_0/dac_in[5] 0.06316f
C41 async_sar_0/a_23428_54264# cdac_8bit_0/dac_in[4] 0.06316f
C42 dout[3] async_sar_0/sample_en 0.07696f
C43 cdac_8bit_0/dac_in[6] cdac_8bit_0/dac_in[4] 0.13725f
C44 async_sar_0/a_20908_46000# async_sar_0/sample_en 0.06751f
C45 dout[0] async_sar_0/sample_en 0.07686f
C46 async_sar_0/a_23428_54264# async_sar_0/sample_en 0.06551f
C47 cdac_8bit_0/dac_in[6] async_sar_0/sample_en 4.31552f
C48 dout[4] dout[5] 0.12306f
C49 dout[6] dout[7] 0.12306f
C50 async_sar_0/a_30228_54264# cdac_8bit_0/dac_in[0] 0.0647f
C51 vref strongarm_comp_0/comp_comp_xor_fast_0/comp_comp_nand_3v3_3/b 0.03793f
C52 async_sar_0/a_37028_54264# cdac_8bit_0/dac_in[0] 0.0647f
C53 async_sar_0/a_50628_54264# cdac_8bit_0/dac_in[4] 0.07054f
C54 vref strongarm_comp_0/comp_comp_xor_fast_0/comp_comp_nand_3v3_2/b 0.02826f
C55 async_sar_0/a_35308_29600# async_sar_0/sample_en 0.06114f
C56 async_sar_0/a_50628_54264# async_sar_0/sample_en 0.0899f
C57 vref cdac_8bit_0/dac_in[6] 0.15082f
C58 vin_p sample_hold_0/clkb 0.01619f
C59 dout[2] async_sar_0/sample_en 0.07696f
C60 cdac_8bit_0/dac_in[4] async_sar_0/sample_en 0.13631f
C61 cdac_8bit_0/dac_in[0] dout[7] 0.06026f
C62 async_sar_0/a_23428_54264# cdac_8bit_0/dac_in[5] 0.06316f
C63 cdac_8bit_0/dac_in[6] cdac_8bit_0/dac_in[5] 9.84171f
C64 async_sar_0/a_43828_54264# cdac_8bit_0/dac_in[6] 0.06316f
C65 dout[3] dout[4] 0.12306f
C66 vref cdac_8bit_0/dac_in[4] 0.20653f
C67 async_sar_0/a_50628_54264# cdac_8bit_0/dac_in[5] 0.07054f
C68 async_sar_0/a_23428_54264# cdac_8bit_0/dac_in[0] 0.0647f
C69 vref async_sar_0/sample_en 0.55635f
C70 cdac_8bit_0/dac_in[6] cdac_8bit_0/dac_in[0] 0.0647f
C71 vin_p async_sar_0/sample_en 0.05565f
C72 cdac_8bit_0/dac_in[4] cdac_8bit_0/dac_in[5] 9.35947f
C73 vref strongarm_comp_0/comp_comp_inv_3v3_0/vi 0.05531f
C74 cdac_8bit_0/dac_in[5] async_sar_0/sample_en 0.13679f
C75 done async_sar_0/sample_en 0.0252f
C76 dout[6] async_sar_0/sample_en 0.07696f
C77 async_sar_0/a_43828_54264# cdac_8bit_0/dac_in[4] 0.06316f
C78 vin_p dvss 0.96824f
C79 sample_hold_0/clkb dvss -0.51475f
C80 async_sar_0/sample_en dvss 30.34163f
C81 cdac_8bit_0/cdac_cdac_switch_1b_7/bit_b dvss -1.09134f
C82 cdac_8bit_0/bot5 dvss -3.98978f
C83 cdac_8bit_0/bot6 dvss -21.89317f
C84 cdac_8bit_0/bot7 dvss -29.93657f
C85 cdac_8bit_0/bot4 dvss -2.61962f
C86 cdac_8bit_0/cdac_cdac_switch_1b_5/bit_b dvss -1.09134f
C87 cdac_8bit_0/dac_in[4] dvss 33.28629f
C88 cdac_8bit_0/cdac_cdac_switch_1b_6/bit_b dvss -1.09134f
C89 cdac_8bit_0/dac_in[6] dvss 33.86838f
C90 cdac_8bit_0/cdac_cdac_switch_1b_4/bit_b dvss -1.09134f
C91 cdac_8bit_0/dac_in[5] dvss 22.4875f
C92 vref dvss -5.99201f
C93 cdac_8bit_0/bot3 dvss -4.45977f
C94 cdac_8bit_0/cdac_cdac_switch_1b_3/bit_b dvss -0.98981f
C95 cdac_8bit_0/bot2 dvss -2.77252f
C96 cdac_8bit_0/cdac_cdac_switch_1b_2/bit_b dvss -0.99253f
C97 cdac_8bit_0/bot1 dvss -1.69004f
C98 cdac_8bit_0/cdac_cdac_switch_1b_1/bit_b dvss -0.99149f
C99 cdac_8bit_0/bot0 dvss -1.11758f
C100 cdac_8bit_0/cdac_cdac_switch_1b_0/bit_b dvss -1.09134f
C101 cdac_8bit_0/dac_in[0] dvss 25.3749f
C102 strongarm_comp_0/comp_comp_xor_fast_0/comp_comp_nand_3v3_3/a dvss -0.64911f
C103 strongarm_comp_0/comp_comp_xor_fast_0/comp_comp_nand_3v3_3/b dvss -0.57915f
C104 strongarm_comp_0/out_n dvss -1.30343f
C105 strongarm_comp_0/comp_comp_xor_fast_0/comp_comp_nand_3v3_2/b dvss -0.95029f
C106 strongarm_comp_0/comp_comp_inv_3v3_1/vi dvss -1.0176f
C107 strongarm_comp_0/comp_comp_inv_3v3_0/vi dvss -0.89606f
C108 done dvss 0.06054f
C109 dout[7] dvss 0.21867f
C110 dout[6] dvss 0.21702f
C111 dout[5] dvss 0.21686f
C112 dout[4] dvss 0.21683f
C113 dout[3] dvss 0.21683f
C114 dout[2] dvss 0.21683f
C115 dout[1] dvss 0.21683f
C116 dout[0] dvss 0.58225f
C117 async_sar_0/a_47028_19064# dvss 0.11454f
C118 async_sar_0/a_33308_24800# dvss 0.1076f
C119 async_sar_0/a_20908_46000# dvss 0.11317f
C120 async_sar_0/a_35308_29600# dvss 0.10179f
C121 async_sar_0/a_50628_54264# dvss 0.5039f
C122 async_sar_0/a_43828_54264# dvss 0.44605f
C123 async_sar_0/a_37028_54264# dvss 0.44597f
C124 async_sar_0/a_30228_54264# dvss 0.44572f
C125 async_sar_0/a_23428_54264# dvss 0.44556f
C126 async_sar_0/a_16628_54264# dvss 0.44515f
C127 async_sar_0/a_9828_54264# dvss 0.46773f
.ends

.subckt sar_adc_chip AVDD VREF AVSS AVSS_GUARD VIN_P AVSS_SHLD NC_W1 NC_W2 DVSS DOUT[7]
Xsar_adc_top_0 sar_adc_top_0/vin_p DVSS DVSS DOUT[7] DOUT[7] DOUT[7] DOUT[7] DOUT[7]
+ DOUT[7] DOUT[7] DOUT[7] sar_adc_top_0/async_sar_0/a_36908_54400# sar_adc_top_0/async_sar_0/a_2908_41600#
+ sar_adc_top_0/async_sar_0/a_34108_29600# sar_adc_top_0/async_sar_0/a_35308_41600#
+ sar_adc_top_0/async_sar_0/a_38108_54400# sar_adc_top_0/async_sar_0/a_8108_10960#
+ sar_adc_top_0/async_sar_0/a_4108_41600# sar_adc_top_0/async_sar_0/a_8108_6160# sar_adc_top_0/async_sar_0/a_37028_54264#
+ sar_adc_top_0/async_sar_0/a_37028_9464# sar_adc_top_0/async_sar_0/a_36908_12400#
+ sar_adc_top_0/async_sar_0/a_5708_10960# sar_adc_top_0/async_sar_0/a_33308_24800#
+ sar_adc_top_0/async_sar_0/a_34108_41600# sar_adc_top_0/async_sar_0/a_7708_46000#
+ sar_adc_top_0/async_sar_0/a_38108_12400# sar_adc_top_0/async_sar_0/a_8108_15760#
+ sar_adc_top_0/async_sar_0/a_2908_33600# sar_adc_top_0/async_sar_0/a_36908_1200#
+ sar_adc_top_0/async_sar_0/a_5708_15760# sar_adc_top_0/async_sar_0/a_38108_6800#
+ sar_adc_top_0/async_sar_0/a_2228_20424# sar_adc_top_0/cdac_8bit_0/dac_in[6] sar_adc_top_0/async_sar_0/a_3428_1424#
+ sar_adc_top_0/async_sar_0/a_2228_6024# sar_adc_top_0/async_sar_0/a_34108_33600#
+ sar_adc_top_0/async_sar_0/a_2908_37600# sar_adc_top_0/cdac_8bit_0/dac_in[5] sar_adc_top_0/async_sar_0/a_38908_41600#
+ sar_adc_top_0/async_sar_0/a_7708_41600# sar_adc_top_0/cdac_8bit_0/dac_in[0] sar_adc_top_0/sample_hold_0/clkb
+ sar_adc_top_0/async_sar_0/a_2228_10824# sar_adc_top_0/strongarm_comp_0/comp_comp_xor_fast_0/comp_comp_nand_3v3_3/b
+ sar_adc_top_0/async_sar_0/a_38228_3864# sar_adc_top_0/async_sar_0/a_34108_37600#
+ sar_adc_top_0/async_sar_0/a_5708_6160# sar_adc_top_0/async_sar_0/a_8108_20560# sar_adc_top_0/async_sar_0/a_36908_50400#
+ sar_adc_top_0/cdac_8bit_0/dac_in[4] sar_adc_top_0/async_sar_0/a_36908_6800# sar_adc_top_0/async_sar_0/a_5708_20560#
+ sar_adc_top_0/async_sar_0/a_2908_29600# sar_adc_top_0/async_sar_0/a_38108_50400#
+ sar_adc_top_0/async_sar_0/a_38108_1200# sar_adc_top_0/async_sar_0/a_35308_29600#
+ DVSS sar_adc_top_0/async_sar_0/a_37028_3864# DVSS sar_adc_top_0/async_sar_0/a_38228_9464#
+ sar_adc_top_0/async_sar_0/a_2228_15624# sar_adc_top
C0 sar_adc_top_0/cdac_8bit_0/dac_in[6] sar_adc_top_0/vin_p 0.20996f
C1 sar_adc_top_0/sample_hold_0/clkb sar_adc_top_0/vin_p 0.05391f
C2 DOUT[7] DVSS 7.82836f
C3 sar_adc_top_0/vin_p DVSS 11.63646f
C4 sar_adc_top_0/sample_hold_0/clkb DVSS -0.55122f
C5 sar_adc_top_0/cdac_8bit_0/cdac_cdac_switch_1b_7/bit_b DVSS -1.09134f
C6 sar_adc_top_0/cdac_8bit_0/bot5 DVSS -3.98978f
C7 sar_adc_top_0/cdac_8bit_0/bot6 DVSS -21.89317f
C8 sar_adc_top_0/cdac_8bit_0/bot7 DVSS -29.91006f
C9 sar_adc_top_0/cdac_8bit_0/bot4 DVSS -2.61962f
C10 sar_adc_top_0/cdac_8bit_0/cdac_cdac_switch_1b_5/bit_b DVSS -1.09134f
C11 sar_adc_top_0/cdac_8bit_0/dac_in[4] DVSS -6.71949f
C12 sar_adc_top_0/cdac_8bit_0/cdac_cdac_switch_1b_6/bit_b DVSS -1.09134f
C13 sar_adc_top_0/cdac_8bit_0/dac_in[6] DVSS -4.57482f
C14 sar_adc_top_0/cdac_8bit_0/cdac_cdac_switch_1b_4/bit_b DVSS -1.09134f
C15 sar_adc_top_0/cdac_8bit_0/dac_in[5] DVSS -7.52778f
C16 sar_adc_top_0/cdac_8bit_0/bot3 DVSS -4.60751f
C17 sar_adc_top_0/cdac_8bit_0/cdac_cdac_switch_1b_3/bit_b DVSS -1.09134f
C18 sar_adc_top_0/cdac_8bit_0/bot2 DVSS -2.92197f
C19 sar_adc_top_0/cdac_8bit_0/cdac_cdac_switch_1b_2/bit_b DVSS -1.09134f
C20 sar_adc_top_0/cdac_8bit_0/bot1 DVSS -1.83883f
C21 sar_adc_top_0/cdac_8bit_0/cdac_cdac_switch_1b_1/bit_b DVSS -1.09134f
C22 sar_adc_top_0/cdac_8bit_0/bot0 DVSS -1.11758f
C23 sar_adc_top_0/cdac_8bit_0/cdac_cdac_switch_1b_0/bit_b DVSS -1.09134f
C24 sar_adc_top_0/cdac_8bit_0/dac_in[0] DVSS -2.70066f
C25 sar_adc_top_0/strongarm_comp_0/comp_comp_xor_fast_0/comp_comp_nand_3v3_3/a DVSS -0.69978f
C26 sar_adc_top_0/strongarm_comp_0/comp_comp_xor_fast_0/comp_comp_nand_3v3_3/b DVSS -0.49023f
C27 sar_adc_top_0/strongarm_comp_0/out_n DVSS -1.32086f
C28 sar_adc_top_0/strongarm_comp_0/comp_comp_xor_fast_0/comp_comp_nand_3v3_2/b DVSS -1.01981f
C29 sar_adc_top_0/strongarm_comp_0/comp_comp_inv_3v3_1/vi DVSS -1.14162f
C30 sar_adc_top_0/strongarm_comp_0/comp_comp_inv_3v3_0/vi DVSS -1.2298f
C31 sar_adc_top_0/async_sar_0/a_38108_1200# DVSS 0.03377f
C32 sar_adc_top_0/async_sar_0/a_36908_1200# DVSS 0.02058f
C33 sar_adc_top_0/async_sar_0/a_3428_1424# DVSS 0.02553f
C34 sar_adc_top_0/async_sar_0/a_38228_3864# DVSS 0.03646f
C35 sar_adc_top_0/async_sar_0/a_37028_3864# DVSS 0.01833f
C36 sar_adc_top_0/async_sar_0/a_5708_6160# DVSS 0.03969f
C37 sar_adc_top_0/async_sar_0/a_8108_6160# DVSS 0.02817f
C38 sar_adc_top_0/async_sar_0/a_2228_6024# DVSS 0.03085f
C39 sar_adc_top_0/async_sar_0/a_38108_6800# DVSS 0.03377f
C40 sar_adc_top_0/async_sar_0/a_36908_6800# DVSS 0.02058f
C41 sar_adc_top_0/async_sar_0/a_38228_9464# DVSS 0.03646f
C42 sar_adc_top_0/async_sar_0/a_37028_9464# DVSS 0.01833f
C43 sar_adc_top_0/async_sar_0/a_5708_10960# DVSS 0.03969f
C44 sar_adc_top_0/async_sar_0/a_8108_10960# DVSS 0.02817f
C45 sar_adc_top_0/async_sar_0/a_2228_10824# DVSS 0.03085f
C46 sar_adc_top_0/async_sar_0/a_38108_12400# DVSS 0.03377f
C47 sar_adc_top_0/async_sar_0/a_36908_12400# DVSS 0.02058f
C48 sar_adc_top_0/async_sar_0/a_5708_15760# DVSS 0.03969f
C49 sar_adc_top_0/async_sar_0/a_8108_15760# DVSS 0.02817f
C50 sar_adc_top_0/async_sar_0/a_2228_15624# DVSS 0.03085f
C51 sar_adc_top_0/async_sar_0/a_5708_20560# DVSS 0.03969f
C52 sar_adc_top_0/async_sar_0/a_8108_20560# DVSS 0.02817f
C53 sar_adc_top_0/async_sar_0/a_2228_20424# DVSS 0.03085f
C54 sar_adc_top_0/async_sar_0/a_33308_24800# DVSS 0.2196f
C55 sar_adc_top_0/async_sar_0/a_34108_29600# DVSS 0.01965f
C56 sar_adc_top_0/async_sar_0/a_2908_29600# DVSS 0.02104f
C57 sar_adc_top_0/async_sar_0/a_34108_33600# DVSS 0.01819f
C58 sar_adc_top_0/async_sar_0/a_2908_33600# DVSS 0.02056f
C59 sar_adc_top_0/async_sar_0/a_34108_37600# DVSS 0.01774f
C60 sar_adc_top_0/async_sar_0/a_2908_37600# DVSS 0.01428f
C61 sar_adc_top_0/async_sar_0/a_38908_41600# DVSS 0.04795f
C62 sar_adc_top_0/async_sar_0/a_34108_41600# DVSS 0.01762f
C63 sar_adc_top_0/async_sar_0/a_35308_41600# DVSS 0.03305f
C64 sar_adc_top_0/async_sar_0/a_7708_41600# DVSS 0.01894f
C65 sar_adc_top_0/async_sar_0/a_2908_41600# DVSS 0.0139f
C66 sar_adc_top_0/async_sar_0/a_4108_41600# DVSS 0.02672f
C67 sar_adc_top_0/async_sar_0/a_8908_46000# DVSS 0.0117f $ **FLOATING
C68 sar_adc_top_0/async_sar_0/a_7708_46000# DVSS 0.02351f
C69 sar_adc_top_0/async_sar_0/a_6508_46000# DVSS 0.01042f $ **FLOATING
C70 sar_adc_top_0/async_sar_0/a_38108_50400# DVSS 0.02091f
C71 sar_adc_top_0/async_sar_0/a_36908_50400# DVSS 0.02438f
C72 sar_adc_top_0/async_sar_0/a_35308_29600# DVSS 0.17863f
C73 sar_adc_top_0/async_sar_0/a_38108_54400# DVSS 0.02092f
C74 sar_adc_top_0/async_sar_0/a_36908_54400# DVSS 0.02415f
C75 sar_adc_top_0/async_sar_0/a_37028_54264# DVSS 0.04867f
C76 sar_adc_top_0/async_sar_0/a_30228_54264# DVSS 0.02144f
.ends
