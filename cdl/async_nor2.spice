.include async_inverter.spice
.include async_nand2.spice

.subckt async_nor2 VDD VSS A B Y
x1 VDD VSS A A_b async_inverter
x2 VDD VSS B B_b async_inverter
x3 VDD VSS A_b B_b net1 async_nand2
x4 VDD VSS net1 Y async_inverter
.ends
