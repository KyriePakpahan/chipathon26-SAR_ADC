* ==============================================================================
* Golden CDL Netlist: 8-Bit Capacitive DAC (CDAC) Array
* PDK: GF180MCU (3.3V)
* ==============================================================================

.subckt cdac_switch_1b bit_b vdd bot bit vss
XM_inv_p bit_b bit vdd vdd pfet_03v3 L=0.28u W=16.0u
XM_inv_n bit_b bit vss vss nfet_03v3 L=0.28u W=8.0u
XM_vref bot bit_b vdd vdd pfet_03v3 L=0.28u W=32.0u
XM_gnd  bot bit_b vss vss nfet_03v3 L=0.28u W=24.0u
.ends

.subckt cdac_8bit vref dac_in[7] dac_in[6] dac_in[5] dac_in[4] dac_in[3] dac_in[2] dac_in[1] dac_in[0] vdac vss
XSW0 bit_b0 vref bot0 dac_in[0] vss cdac_switch_1b
XC0 vdac bot0 cap_mim_2f0fF c_width=5e-6 c_length=5e-6
XSW1 bit_b1 vref bot1 dac_in[1] vss cdac_switch_1b
XC1 vdac bot1 cap_mim_2f0fF c_width=5e-6 c_length=5e-6 m=2
XSW2 bit_b2 vref bot2 dac_in[2] vss cdac_switch_1b
XC2 vdac bot2 cap_mim_2f0fF c_width=5e-6 c_length=5e-6 m=4
XSW3 bit_b3 vref bot3 dac_in[3] vss cdac_switch_1b
XC3 vdac bot3 cap_mim_2f0fF c_width=5e-6 c_length=5e-6 m=8
XSW4 bit_b4 vref bot4 dac_in[4] vss cdac_switch_1b
XC4 vdac bot4 cap_mim_2f0fF c_width=5e-6 c_length=5e-6 m=16
XSW5 bit_b5 vref bot5 dac_in[5] vss cdac_switch_1b
XC5 vdac bot5 cap_mim_2f0fF c_width=5e-6 c_length=5e-6 m=32
XSW6 bit_b6 vref bot6 dac_in[6] vss cdac_switch_1b
XC6 vdac bot6 cap_mim_2f0fF c_width=5e-6 c_length=5e-6 m=64
XSW7 bit_b7 vref bot7 dac_in[7] vss cdac_switch_1b
XC7 vdac bot7 cap_mim_2f0fF c_width=5e-6 c_length=5e-6 m=128
XC_dummy vdac vss cap_mim_2f0fF c_width=5e-6 c_length=5e-6
.ends
