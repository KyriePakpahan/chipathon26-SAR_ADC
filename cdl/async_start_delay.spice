.include async_inverter.spice

.subckt async_start_delay VDD VSS in out
x1 VDD VSS in net1 async_inverter
x2 VDD VSS net1 net2 async_inverter
x3 VDD VSS net2 net3 async_inverter
x4 VDD VSS net3 net4 async_inverter
x5 VDD VSS net4 net5 async_inverter
x6 VDD VSS net5 net6 async_inverter
x7 VDD VSS net6 net7 async_inverter
x8 VDD VSS net7 net8 async_inverter
x9 VDD VSS net8 net9 async_inverter
x10 VDD VSS net9 net10 async_inverter
x11 VDD VSS net10 net11 async_inverter
x12 VDD VSS net11 net12 async_inverter
x13 VDD VSS net12 net13 async_inverter
x14 VDD VSS net13 net14 async_inverter
x15 VDD VSS net14 net15 async_inverter
x16 VDD VSS net15 net16 async_inverter
x17 VDD VSS net16 net17 async_inverter
x18 VDD VSS net17 net18 async_inverter
x19 VDD VSS net18 net19 async_inverter
x20 VDD VSS net19 net20 async_inverter
x21 VDD VSS net20 net21 async_inverter
x22 VDD VSS net21 net22 async_inverter
x23 VDD VSS net22 net23 async_inverter
x24 VDD VSS net23 net24 async_inverter
x25 VDD VSS net24 net25 async_inverter
x26 VDD VSS net25 net26 async_inverter
x27 VDD VSS net26 net27 async_inverter
x28 VDD VSS net27 net28 async_inverter
x29 VDD VSS net28 net29 async_inverter
x30 VDD VSS net29 net30 async_inverter
x31 VDD VSS net30 net31 async_inverter
x32 VDD VSS net31 net32 async_inverter
x33 VDD VSS net32 net33 async_inverter
x34 VDD VSS net33 net34 async_inverter
x35 VDD VSS net34 net35 async_inverter
x36 VDD VSS net35 net36 async_inverter
x37 VDD VSS net36 net37 async_inverter
x38 VDD VSS net37 net38 async_inverter
x39 VDD VSS net38 net39 async_inverter
x40 VDD VSS net39 net40 async_inverter
x41 VDD VSS net40 net41 async_inverter
x42 VDD VSS net41 net42 async_inverter
x43 VDD VSS net42 net43 async_inverter
x44 VDD VSS net43 net44 async_inverter
x45 VDD VSS net44 out async_inverter
.ends
