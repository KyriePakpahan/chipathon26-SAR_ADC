.include async_inverter.spice
.include async_nand2.spice
.include async_nor2.spice

.subckt bit_reg VDD VSS comp_out en rst_n bit_out
x_nand_set VDD VSS comp_out en set_n async_nand2
x_inv_set VDD VSS set_n set async_inverter
x_inv_rst VDD VSS rst_n rst async_inverter
x_nor_q VDD VSS rst bit_out_bar bit_out async_nor2
x_nor_qb VDD VSS set bit_out bit_out_bar async_nor2
.ends
