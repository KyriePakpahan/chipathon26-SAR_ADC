* ==============================================================================
* Golden Full-Hierarchy Netlist: async_sar (Asynchronous SAR Logic Controller)
* PDK: GlobalFoundries GF180MCU (gf180mcuD, 3.3V)
* ==============================================================================

.include async_inverter.spice
.include async_nand2.spice
.include async_nor2.spice
.include dff_cell.spice
.include dff_cell_set.spice
.include shift_reg_8bit.spice
.include bit_reg.spice
.include async_delay_chain.spice
.include async_start_delay.spice
.include async_pulse_settle.spice

.subckt async_sar comp_out_p dout[0] dac_in[0] dout[1] dac_in[1] dout[2] dac_in[2] dout[3] dac_in[3] dout[4] dac_in[4] dout[5] dac_in[5] dout[6] dac_in[6] dout[7] dac_in[7] start comp_done done sample_en rst_latch vdd vss

* Control & Handshake Logic
X_isrc  vdd vss comp_done comp_done_b async_inverter
X_irst  vdd vss start rst_n_int async_inverter
X_ise1  vdd vss start se_n async_inverter
X_ise2  vdd vss se_n sample_en async_inverter
X_idn   vdd vss done_n_int done async_inverter
X_idnv  vdd vss done done_n async_inverter
X_psettle vdd vss comp_done gate_settle async_pulse_settle
X_stdel vdd vss start start_n async_start_delay
X_ndn   vdd vss Q7 comp_done done_n_int async_nand2
X_nctl  vdd vss start_n done_n gate_ctrl async_nand2
X_nrst  vdd vss gate_settle gate_ctrl rst_latch async_nor2

* 8-Bit Shift Register Ring Counter
X_sr8 vss Q1 Q2 Q3 Q4 Q5 Q6 Q7 open_done comp_done_b rst_n_int vdd vss Q0 shift_reg_8bit

* 8x Bit Registers (SR-Latch SAR Data Registers)
X_bit0 vdd vss comp_out_p Q7 rst_n_int dout[0] bit_reg
X_bit1 vdd vss comp_out_p Q6 rst_n_int dout[1] bit_reg
X_bit2 vdd vss comp_out_p Q5 rst_n_int dout[2] bit_reg
X_bit3 vdd vss comp_out_p Q4 rst_n_int dout[3] bit_reg
X_bit4 vdd vss comp_out_p Q3 rst_n_int dout[4] bit_reg
X_bit5 vdd vss comp_out_p Q2 rst_n_int dout[5] bit_reg
X_bit6 vdd vss comp_out_p Q1 rst_n_int dout[6] bit_reg
X_bit7 vdd vss comp_out_p Q0 rst_n_int dout[7] bit_reg

* First Stage DAC NORs (nor_dq)
X_nor_dq0 vdd vss dout[0] Q7 dac_n0 async_nor2
X_nor_dq1 vdd vss dout[1] Q6 dac_n1 async_nor2
X_nor_dq2 vdd vss dout[2] Q5 dac_n2 async_nor2
X_nor_dq3 vdd vss dout[3] Q4 dac_n3 async_nor2
X_nor_dq4 vdd vss dout[4] Q3 dac_n4 async_nor2
X_nor_dq5 vdd vss dout[5] Q2 dac_n5 async_nor2
X_nor_dq6 vdd vss dout[6] Q1 dac_n6 async_nor2
X_nor_dq7 vdd vss dout[7] Q0 dac_n7 async_nor2

* Second Stage DAC NORs (nor_st)
X_nor_st0 vdd vss dac_n0 start dac_in[0] async_nor2
X_nor_st1 vdd vss dac_n1 start dac_in[1] async_nor2
X_nor_st2 vdd vss dac_n2 start dac_in[2] async_nor2
X_nor_st3 vdd vss dac_n3 start dac_in[3] async_nor2
X_nor_st4 vdd vss dac_n4 start dac_in[4] async_nor2
X_nor_st5 vdd vss dac_n5 start dac_in[5] async_nor2
X_nor_st6 vdd vss dac_n6 start dac_in[6] async_nor2
X_nor_st7 vdd vss dac_n7 start dac_in[7] async_nor2

.ends
