* ==============================================================================
* Monolithic 8-bit 10 MS/s Asynchronous SAR ADC Top-Level CDL Netlist
* PDK: GF180MCU (Variant D, 3.3V)
* ==============================================================================

.include sample_hold.spice
.include cdac_8bit.spice
.include strongarm_comp.spice
.include async_sar.spice

.subckt sar_adc_top vin vref start done vdd vss dout[0] dout[1] dout[2] dout[3] dout[4] dout[5] dout[6] dout[7]
x_sh vin sample_en vhold vdd vss sample_hold
x_cdac vref dac_in[7] dac_in[6] dac_in[5] dac_in[4] dac_in[3] dac_in[2] dac_in[1] dac_in[0] vdac vss cdac_8bit
x_comp vdd vss comp_done comp_out_p comp_out_n vhold vdac rst_latch strongarm_comp
x_sar comp_out_p dout[0] dac_in[0] dout[1] dac_in[1] dout[2] dac_in[2] dout[3] dac_in[3] dout[4] dac_in[4] dout[5] dac_in[5] dout[6] dac_in[6] dout[7] dac_in[7] start comp_done done sample_en rst_latch vdd vss async_sar
.ends
