* ==============================================================================
* Golden CDL Netlist: Dynamic StrongARM Comparator with Handshake Completion
* PDK: GF180MCU (3.3V)
* ==============================================================================

.subckt strongarm_comp rst_latch out_p out_n vdd comp_done vin_p vin_n vss
* StrongARM Core Pre-charge / Reset PMOS
M1 out_p rst_latch vdd vdd pfet_03v3 L=0.28u W=0.42u
M2 out_n rst_latch vdd vdd pfet_03v3 L=0.28u W=0.42u
M3 net_p rst_latch vdd vdd pfet_03v3 L=0.28u W=0.42u
M4 net_n rst_latch vdd vdd pfet_03v3 L=0.28u W=0.42u

* Cross-coupled PMOS regeneration latch
M5 out_p out_n vdd vdd pfet_03v3 L=0.28u W=0.42u
M6 out_n out_p vdd vdd pfet_03v3 L=0.28u W=0.42u

* Cross-coupled NMOS latch
M7 out_p out_n net_p vss nfet_03v3 L=0.28u W=0.42u
M8 out_n out_p net_n vss nfet_03v3 L=0.28u W=0.42u

* Differential Input Pair
M9 net_p vin_p net_tail vss nfet_03v3 L=0.28u W=0.42u
M10 net_n vin_n net_tail vss nfet_03v3 L=0.28u W=0.42u

* Tail NMOS current source / enable switch
M11 net_tail rst_latch vss vss nfet_03v3 L=0.28u W=0.5u

* Handshake Completion Logic: Inverter on rst_latch -> n_rst_b
M12 n_rst_b rst_latch vdd vdd pfet_03v3 L=0.28u W=0.8u
M13 n_rst_b rst_latch vss vss nfet_03v3 L=0.28u W=0.42u

* Handshake Completion Logic: NAND2 on (out_n, out_p) -> n_done_raw
M14 n_done_raw out_n vdd vdd pfet_03v3 L=0.28u W=1.0u
M15 n_done_raw out_p vdd vdd pfet_03v3 L=0.28u W=1.0u
M16 n_done_raw out_n net_nand vss nfet_03v3 L=0.28u W=0.5u
M17 net_nand out_p vss vss nfet_03v3 L=0.28u W=0.5u

* Pull-down NMOS on n_done_raw during reset
M18 n_done_raw n_rst_b vss vss nfet_03v3 L=0.28u W=0.5u

* Output Buffer Inverter 1 -> n_done_d1
M19 n_done_d1 n_done_raw vdd vdd pfet_03v3 L=0.28u W=0.8u
M20 n_done_d1 n_done_raw vss vss nfet_03v3 L=0.28u W=0.42u

* Output Buffer Inverter 2 -> comp_done
M21 comp_done n_done_d1 vdd vdd pfet_03v3 L=0.28u W=0.8u
M22 comp_done n_done_d1 vss vss nfet_03v3 L=0.28u W=0.42u
.ends
