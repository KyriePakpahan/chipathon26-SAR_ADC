.include async_inverter.spice
.include dff_cell.spice

.subckt dff_cell_set VDD VSS D clk rst_n Q
x_inv_d VDD VSS D D_b async_inverter
x_dff VDD VSS clk D_b rst_n Q_bar dff_cell
x_inv_q VDD VSS Q_bar Q async_inverter
.ends
