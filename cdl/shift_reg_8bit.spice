.include dff_cell_set.spice
.include dff_cell.spice

.subckt shift_reg_8bit VDD VSS serial_in clk rst_n Q0 Q1 Q2 Q3 Q4 Q5 Q6 Q7 done
x1 VDD VSS serial_in clk rst_n Q0 dff_cell_set
x2 VDD VSS clk Q0 rst_n Q1 dff_cell
x3 VDD VSS clk Q1 rst_n Q2 dff_cell
x4 VDD VSS clk Q2 rst_n Q3 dff_cell
x5 VDD VSS clk Q3 rst_n Q4 dff_cell
x6 VDD VSS clk Q4 rst_n Q5 dff_cell
x7 VDD VSS clk Q5 rst_n Q6 dff_cell
x8 VDD VSS clk Q6 rst_n Q7 dff_cell
x9 VDD VSS clk Q7 rst_n done dff_cell
.ends
