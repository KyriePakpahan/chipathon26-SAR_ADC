* ==============================================================================
* Golden CDL Netlist: CMOS Transmission Gate Sample & Hold Circuit
* PDK: GF180MCU (3.3V)
* ==============================================================================

.subckt sample_hold vin sample_en vhold vdd vss
* Sampling Switch PMOS (W=8u, L=0.28u)
X_tg_p vin clkb vhold vdd pfet_03v3 w=8.0u l=0.28u
* Sampling Switch NMOS (W=4u, L=0.28u)
X_tg_n vin sample_en vhold vss nfet_03v3 w=4.0u l=0.28u
* Clock Inverter PMOS (W=2u, L=0.28u)
X_inv_p clkb sample_en vdd vdd pfet_03v3 w=2.0u l=0.28u
* Clock Inverter NMOS (W=1u, L=0.28u)
X_inv_n clkb sample_en vss vss nfet_03v3 w=1.0u l=0.28u
* Hold Capacitor (15u x 10u MIM Cap)
X_cap vhold vss cap_mim_2f0_m4m5_noshield c_width=15u c_length=10u
.ends
