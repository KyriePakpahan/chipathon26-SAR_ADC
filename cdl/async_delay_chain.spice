.include async_inverter.spice

.subckt async_delay_chain VDD VSS in out
x1 VDD VSS in net1 async_inverter
x2 VDD VSS net1 net2 async_inverter
x3 VDD VSS net2 net3 async_inverter
x4 VDD VSS net3 net4 async_inverter
x5 VDD VSS net4 net5 async_inverter
x6 VDD VSS net5 net6 async_inverter
x7 VDD VSS net6 net7 async_inverter
x8 VDD VSS net7 net8 async_inverter
x9 VDD VSS net8 net9 async_inverter
x10 VDD VSS net9 net10 async_inverter
x11 VDD VSS net10 net11 async_inverter
x12 VDD VSS net11 net12 async_inverter
x13 VDD VSS net12 net13 async_inverter
x14 VDD VSS net13 net14 async_inverter
x15 VDD VSS net14 net15 async_inverter
x16 VDD VSS net15 net16 async_inverter
x17 VDD VSS net16 net17 async_inverter
x18 VDD VSS net17 net18 async_inverter
x19 VDD VSS net18 net19 async_inverter
x20 VDD VSS net19 net20 async_inverter
x21 VDD VSS net20 out async_inverter
.ends
